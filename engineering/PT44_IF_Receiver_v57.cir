PT-44 v0.57 joint hot DC IF/detector/audio/power - uncalibrated
* Factory topology: Philco p.38. Load resistors, field L and lamp hot R are test inputs.
* B-minus is the reference; no chassis bond. Rectifier is a single-point 3/2-power approximation.
VMAIN LINE 0 115
VLINE_LINK LINE LINE_IN 0
R30_40 LINE_IN PLATE 40
RLAMP LINE_IN PLATE 42
R30_80 PLATE HEATER_IN 80
RHEATERS HEATER_IN 0 692.6666666666667
BRECT PLATE N_BPLUS_RECT I={1*0.0026189140043946205*max(V(PLATE,N_BPLUS_RECT),0)^1.5}
C29A N_BPLUS_RECT 0 0.00002
C29B N_BPLUS_FILT 0 0.00002
VFIELD N_BPLUS_RECT FIELD_IN 0
R28 FIELD_IN FIELD_L 500
LFIELD FIELD_L N_BPLUS_FILT 5
* A/B are supplied rails. Transformer secondary is reflected, not galvanically bonded to B-minus.
.func TRI(p,g) {(g<=-4?(p<=0?0:(p<50?(0+(0)*(p-0)/50):(p<100?(0+(0)*(p-50)/50):(p<150?(0+(0)*(p-100)/50):(p<200?(0+(0)*(p-150)/50):(p<250?(0+(0)*(p-200)/50):0)))))):(g<-3?((p<=0?0:(p<50?(0+(0)*(p-0)/50):(p<100?(0+(0)*(p-50)/50):(p<150?(0+(0)*(p-100)/50):(p<200?(0+(0)*(p-150)/50):(p<250?(0+(0)*(p-200)/50):0))))))+((p<=0?0:(p<50?(0+(0)*(p-0)/50):(p<100?(0+(0)*(p-50)/50):(p<150?(0+(0)*(p-100)/50):(p<200?(0+(0)*(p-150)/50):(p<250?(0+(0.00004)*(p-200)/50):0.00004))))))-(p<=0?0:(p<50?(0+(0)*(p-0)/50):(p<100?(0+(0)*(p-50)/50):(p<150?(0+(0)*(p-100)/50):(p<200?(0+(0)*(p-150)/50):(p<250?(0+(0)*(p-200)/50):0)))))))*(g-(-4))/1):(g<-2?((p<=0?0:(p<50?(0+(0)*(p-0)/50):(p<100?(0+(0)*(p-50)/50):(p<150?(0+(0)*(p-100)/50):(p<200?(0+(0)*(p-150)/50):(p<250?(0+(0.00004)*(p-200)/50):0.00004))))))+((p<=0?0:(p<50?(0+(0)*(p-0)/50):(p<100?(0+(0)*(p-50)/50):(p<150?(0+(0)*(p-100)/50):(p<200?(0+(0.00015)*(p-150)/50):(p<250?(0.00015+(0.00025)*(p-200)/50):0.0004))))))-(p<=0?0:(p<50?(0+(0)*(p-0)/50):(p<100?(0+(0)*(p-50)/50):(p<150?(0+(0)*(p-100)/50):(p<200?(0+(0)*(p-150)/50):(p<250?(0+(0.00004)*(p-200)/50):0.00004)))))))*(g-(-3))/1):(g<-1.5?((p<=0?0:(p<50?(0+(0)*(p-0)/50):(p<100?(0+(0)*(p-50)/50):(p<150?(0+(0)*(p-100)/50):(p<200?(0+(0.00015)*(p-150)/50):(p<250?(0.00015+(0.00025)*(p-200)/50):0.0004))))))+((p<=0?0:(p<50?(0+(0)*(p-0)/50):(p<100?(0+(0)*(p-50)/50):(p<150?(0+(0.0001)*(p-100)/50):(p<200?(0.0001+(0.00030000000000000003)*(p-150)/50):(p<250?(0.0004+(0.0003199999999999999)*(p-200)/50):0.0007199999999999999))))))-(p<=0?0:(p<50?(0+(0)*(p-0)/50):(p<100?(0+(0)*(p-50)/50):(p<150?(0+(0)*(p-100)/50):(p<200?(0+(0.00015)*(p-150)/50):(p<250?(0.00015+(0.00025)*(p-200)/50):0.0004)))))))*(g-(-2))/0.5):(g<-1?((p<=0?0:(p<50?(0+(0)*(p-0)/50):(p<100?(0+(0)*(p-50)/50):(p<150?(0+(0.0001)*(p-100)/50):(p<200?(0.0001+(0.00030000000000000003)*(p-150)/50):(p<250?(0.0004+(0.0003199999999999999)*(p-200)/50):0.0007199999999999999))))))+((p<=0?0:(p<50?(0+(0)*(p-0)/50):(p<100?(0+(0.00008)*(p-50)/50):(p<150?(0.00008+(0.00032)*(p-100)/50):(p<200?(0.0004+(0.00041999999999999996)*(p-150)/50):(p<250?(0.00082+(0.00047999999999999996)*(p-200)/50):0.0013))))))-(p<=0?0:(p<50?(0+(0)*(p-0)/50):(p<100?(0+(0)*(p-50)/50):(p<150?(0+(0.0001)*(p-100)/50):(p<200?(0.0001+(0.00030000000000000003)*(p-150)/50):(p<250?(0.0004+(0.0003199999999999999)*(p-200)/50):0.0007199999999999999)))))))*(g-(-1.5))/0.5):(g<-0.5?((p<=0?0:(p<50?(0+(0)*(p-0)/50):(p<100?(0+(0.00008)*(p-50)/50):(p<150?(0.00008+(0.00032)*(p-100)/50):(p<200?(0.0004+(0.00041999999999999996)*(p-150)/50):(p<250?(0.00082+(0.00047999999999999996)*(p-200)/50):0.0013))))))+((p<=0?0:(p<50?(0+(0.00008)*(p-0)/50):(p<100?(0.00008+(0.00039)*(p-50)/50):(p<150?(0.00047+(0.00048)*(p-100)/50):(p<200?(0.00095+(0.0004999999999999999)*(p-150)/50):(p<250?(0.00145+(0.0004000000000000002)*(p-200)/50):0.00185))))))-(p<=0?0:(p<50?(0+(0)*(p-0)/50):(p<100?(0+(0.00008)*(p-50)/50):(p<150?(0.00008+(0.00032)*(p-100)/50):(p<200?(0.0004+(0.00041999999999999996)*(p-150)/50):(p<250?(0.00082+(0.00047999999999999996)*(p-200)/50):0.0013)))))))*(g-(-1))/0.5):(g<0?((p<=0?0:(p<50?(0+(0.00008)*(p-0)/50):(p<100?(0.00008+(0.00039)*(p-50)/50):(p<150?(0.00047+(0.00048)*(p-100)/50):(p<200?(0.00095+(0.0004999999999999999)*(p-150)/50):(p<250?(0.00145+(0.0004000000000000002)*(p-200)/50):0.00185))))))+((p<=0?0:(p<50?(0+(0.00035)*(p-0)/50):(p<100?(0.00035+(0.00065)*(p-50)/50):(p<150?(0.001+(0.0005)*(p-100)/50):(p<200?(0.0015+(0.0005)*(p-150)/50):(p<250?(0.002+(0.0005)*(p-200)/50):0.0025))))))-(p<=0?0:(p<50?(0+(0.00008)*(p-0)/50):(p<100?(0.00008+(0.00039)*(p-50)/50):(p<150?(0.00047+(0.00048)*(p-100)/50):(p<200?(0.00095+(0.0004999999999999999)*(p-150)/50):(p<250?(0.00145+(0.0004000000000000002)*(p-200)/50):0.00185)))))))*(g-(-0.5))/0.5):(g<0.5?((p<=0?0:(p<50?(0+(0.00035)*(p-0)/50):(p<100?(0.00035+(0.00065)*(p-50)/50):(p<150?(0.001+(0.0005)*(p-100)/50):(p<200?(0.0015+(0.0005)*(p-150)/50):(p<250?(0.002+(0.0005)*(p-200)/50):0.0025))))))+((p<=0?0:(p<50?(0+(0.00065)*(p-0)/50):(p<100?(0.00065+(0.0007999999999999999)*(p-50)/50):(p<150?(0.00145+(0.0005500000000000001)*(p-100)/50):(p<200?(0.002+(0.0005499999999999997)*(p-150)/50):(p<250?(0.0025499999999999997+(0.0005500000000000001)*(p-200)/50):0.0031))))))-(p<=0?0:(p<50?(0+(0.00035)*(p-0)/50):(p<100?(0.00035+(0.00065)*(p-50)/50):(p<150?(0.001+(0.0005)*(p-100)/50):(p<200?(0.0015+(0.0005)*(p-150)/50):(p<250?(0.002+(0.0005)*(p-200)/50):0.0025)))))))*(g-(0))/0.5):(g<1?((p<=0?0:(p<50?(0+(0.00065)*(p-0)/50):(p<100?(0.00065+(0.0007999999999999999)*(p-50)/50):(p<150?(0.00145+(0.0005500000000000001)*(p-100)/50):(p<200?(0.002+(0.0005499999999999997)*(p-150)/50):(p<250?(0.0025499999999999997+(0.0005500000000000001)*(p-200)/50):0.0031))))))+((p<=0?0:(p<50?(0+(0.001)*(p-0)/50):(p<100?(0.001+(0.0009)*(p-50)/50):(p<150?(0.0019+(0.0006000000000000001)*(p-100)/50):(p<200?(0.0025+(0.0005999999999999998)*(p-150)/50):(p<250?(0.0031+(0.0005500000000000001)*(p-200)/50):0.00365))))))-(p<=0?0:(p<50?(0+(0.00065)*(p-0)/50):(p<100?(0.00065+(0.0007999999999999999)*(p-50)/50):(p<150?(0.00145+(0.0005500000000000001)*(p-100)/50):(p<200?(0.002+(0.0005499999999999997)*(p-150)/50):(p<250?(0.0025499999999999997+(0.0005500000000000001)*(p-200)/50):0.0031)))))))*(g-(0.5))/0.5):(p<=0?0:(p<50?(0+(0.001)*(p-0)/50):(p<100?(0.001+(0.0009)*(p-50)/50):(p<150?(0.0019+(0.0006000000000000001)*(p-100)/50):(p<200?(0.0025+(0.0005999999999999998)*(p-150)/50):(p<250?(0.0031+(0.0005500000000000001)*(p-200)/50):0.00365)))))))))))))))}
.func OUTP(p,g) {(g<=-20?(p<=0?0:(p<10?(0+(0)*(p-0)/10):(p<25?(0+(0)*(p-10)/15):(p<50?(0+(0)*(p-25)/25):(p<100?(0+(0)*(p-50)/50):(p<110?(0+(0)*(p-100)/10):(p<200?(0+(0)*(p-110)/90):(p<300?(0+(0)*(p-200)/100):(p<400?(0+(0)*(p-300)/100):0))))))))):(g<-16?((p<=0?0:(p<10?(0+(0)*(p-0)/10):(p<25?(0+(0)*(p-10)/15):(p<50?(0+(0)*(p-25)/25):(p<100?(0+(0)*(p-50)/50):(p<110?(0+(0)*(p-100)/10):(p<200?(0+(0)*(p-110)/90):(p<300?(0+(0)*(p-200)/100):(p<400?(0+(0)*(p-300)/100):0)))))))))+((p<=0?0:(p<10?(0+(0.00025)*(p-0)/10):(p<25?(0.00025+(0.00055)*(p-10)/15):(p<50?(0.0008+(0.00019999999999999998)*(p-25)/25):(p<100?(0.001+(0.001)*(p-50)/50):(p<110?(0.002+(0.0002000000000000001)*(p-100)/10):(p<200?(0.0022+(0.0018)*(p-110)/90):(p<300?(0.004+(0.002)*(p-200)/100):(p<400?(0.006+(0.002)*(p-300)/100):0.008)))))))))-(p<=0?0:(p<10?(0+(0)*(p-0)/10):(p<25?(0+(0)*(p-10)/15):(p<50?(0+(0)*(p-25)/25):(p<100?(0+(0)*(p-50)/50):(p<110?(0+(0)*(p-100)/10):(p<200?(0+(0)*(p-110)/90):(p<300?(0+(0)*(p-200)/100):(p<400?(0+(0)*(p-300)/100):0))))))))))*(g-(-20))/4):(g<-12?((p<=0?0:(p<10?(0+(0.00025)*(p-0)/10):(p<25?(0.00025+(0.00055)*(p-10)/15):(p<50?(0.0008+(0.00019999999999999998)*(p-25)/25):(p<100?(0.001+(0.001)*(p-50)/50):(p<110?(0.002+(0.0002000000000000001)*(p-100)/10):(p<200?(0.0022+(0.0018)*(p-110)/90):(p<300?(0.004+(0.002)*(p-200)/100):(p<400?(0.006+(0.002)*(p-300)/100):0.008)))))))))+((p<=0?0:(p<10?(0+(0.003)*(p-0)/10):(p<25?(0.003+(0.006600000000000001)*(p-10)/15):(p<50?(0.009600000000000001+(0.0023999999999999994)*(p-25)/25):(p<100?(0.012+(0.005000000000000001)*(p-50)/50):(p<110?(0.017+(0.0005000000000000004)*(p-100)/10):(p<200?(0.0175+(0.0024999999999999988)*(p-110)/90):(p<300?(0.02+(0.0019999999999999983)*(p-200)/100):(p<400?(0.022+(0.0020000000000000018)*(p-300)/100):0.024)))))))))-(p<=0?0:(p<10?(0+(0.00025)*(p-0)/10):(p<25?(0.00025+(0.00055)*(p-10)/15):(p<50?(0.0008+(0.00019999999999999998)*(p-25)/25):(p<100?(0.001+(0.001)*(p-50)/50):(p<110?(0.002+(0.0002000000000000001)*(p-100)/10):(p<200?(0.0022+(0.0018)*(p-110)/90):(p<300?(0.004+(0.002)*(p-200)/100):(p<400?(0.006+(0.002)*(p-300)/100):0.008))))))))))*(g-(-16))/4):(g<-10?((p<=0?0:(p<10?(0+(0.003)*(p-0)/10):(p<25?(0.003+(0.006600000000000001)*(p-10)/15):(p<50?(0.009600000000000001+(0.0023999999999999994)*(p-25)/25):(p<100?(0.012+(0.005000000000000001)*(p-50)/50):(p<110?(0.017+(0.0005000000000000004)*(p-100)/10):(p<200?(0.0175+(0.0024999999999999988)*(p-110)/90):(p<300?(0.02+(0.0019999999999999983)*(p-200)/100):(p<400?(0.022+(0.0020000000000000018)*(p-300)/100):0.024)))))))))+((p<=0?0:(p<10?(0+(0.006)*(p-0)/10):(p<25?(0.006+(0.013200000000000002)*(p-10)/15):(p<50?(0.019200000000000002+(0.004799999999999999)*(p-25)/25):(p<100?(0.024+(0.005999999999999998)*(p-50)/50):(p<110?(0.03+(0.0005000000000000004)*(p-100)/10):(p<200?(0.0305+(0.0025000000000000022)*(p-110)/90):(p<300?(0.033+(0.0020000000000000018)*(p-200)/100):(p<400?(0.035+(0.001999999999999995)*(p-300)/100):0.037)))))))))-(p<=0?0:(p<10?(0+(0.003)*(p-0)/10):(p<25?(0.003+(0.006600000000000001)*(p-10)/15):(p<50?(0.009600000000000001+(0.0023999999999999994)*(p-25)/25):(p<100?(0.012+(0.005000000000000001)*(p-50)/50):(p<110?(0.017+(0.0005000000000000004)*(p-100)/10):(p<200?(0.0175+(0.0024999999999999988)*(p-110)/90):(p<300?(0.02+(0.0019999999999999983)*(p-200)/100):(p<400?(0.022+(0.0020000000000000018)*(p-300)/100):0.024))))))))))*(g-(-12))/2):(g<-8?((p<=0?0:(p<10?(0+(0.006)*(p-0)/10):(p<25?(0.006+(0.013200000000000002)*(p-10)/15):(p<50?(0.019200000000000002+(0.004799999999999999)*(p-25)/25):(p<100?(0.024+(0.005999999999999998)*(p-50)/50):(p<110?(0.03+(0.0005000000000000004)*(p-100)/10):(p<200?(0.0305+(0.0025000000000000022)*(p-110)/90):(p<300?(0.033+(0.0020000000000000018)*(p-200)/100):(p<400?(0.035+(0.001999999999999995)*(p-300)/100):0.037)))))))))+((p<=0?0:(p<10?(0+(0.0095)*(p-0)/10):(p<25?(0.0095+(0.020900000000000002)*(p-10)/15):(p<50?(0.030400000000000003+(0.007599999999999996)*(p-25)/25):(p<100?(0.038+(0.006999999999999999)*(p-50)/50):(p<110?(0.045+(0.0005000000000000004)*(p-100)/10):(p<200?(0.0455+(0.004500000000000004)*(p-110)/90):(p<300?(0.05+(0.0029999999999999957)*(p-200)/100):(p<400?(0.053+(0.0020000000000000018)*(p-300)/100):0.055)))))))))-(p<=0?0:(p<10?(0+(0.006)*(p-0)/10):(p<25?(0.006+(0.013200000000000002)*(p-10)/15):(p<50?(0.019200000000000002+(0.004799999999999999)*(p-25)/25):(p<100?(0.024+(0.005999999999999998)*(p-50)/50):(p<110?(0.03+(0.0005000000000000004)*(p-100)/10):(p<200?(0.0305+(0.0025000000000000022)*(p-110)/90):(p<300?(0.033+(0.0020000000000000018)*(p-200)/100):(p<400?(0.035+(0.001999999999999995)*(p-300)/100):0.037))))))))))*(g-(-10))/2):(g<-7.5?((p<=0?0:(p<10?(0+(0.0095)*(p-0)/10):(p<25?(0.0095+(0.020900000000000002)*(p-10)/15):(p<50?(0.030400000000000003+(0.007599999999999996)*(p-25)/25):(p<100?(0.038+(0.006999999999999999)*(p-50)/50):(p<110?(0.045+(0.0005000000000000004)*(p-100)/10):(p<200?(0.0455+(0.004500000000000004)*(p-110)/90):(p<300?(0.05+(0.0029999999999999957)*(p-200)/100):(p<400?(0.053+(0.0020000000000000018)*(p-300)/100):0.055)))))))))+((p<=0?0:(p<10?(0+(0.01025)*(p-0)/10):(p<25?(0.01025+(0.02255)*(p-10)/15):(p<50?(0.0328+(0.008199999999999999)*(p-25)/25):(p<100?(0.041+(0.007229999999999993)*(p-50)/50):(p<110?(0.048229999999999995+(0.0007700000000000068)*(p-100)/10):(p<200?(0.049+(0.003999999999999997)*(p-110)/90):(p<300?(0.053+(0.0030000000000000027)*(p-200)/100):(p<400?(0.056+(0.0020000000000000018)*(p-300)/100):0.058)))))))))-(p<=0?0:(p<10?(0+(0.0095)*(p-0)/10):(p<25?(0.0095+(0.020900000000000002)*(p-10)/15):(p<50?(0.030400000000000003+(0.007599999999999996)*(p-25)/25):(p<100?(0.038+(0.006999999999999999)*(p-50)/50):(p<110?(0.045+(0.0005000000000000004)*(p-100)/10):(p<200?(0.0455+(0.004500000000000004)*(p-110)/90):(p<300?(0.05+(0.0029999999999999957)*(p-200)/100):(p<400?(0.053+(0.0020000000000000018)*(p-300)/100):0.055))))))))))*(g-(-8))/0.5):(g<-6?((p<=0?0:(p<10?(0+(0.01025)*(p-0)/10):(p<25?(0.01025+(0.02255)*(p-10)/15):(p<50?(0.0328+(0.008199999999999999)*(p-25)/25):(p<100?(0.041+(0.007229999999999993)*(p-50)/50):(p<110?(0.048229999999999995+(0.0007700000000000068)*(p-100)/10):(p<200?(0.049+(0.003999999999999997)*(p-110)/90):(p<300?(0.053+(0.0030000000000000027)*(p-200)/100):(p<400?(0.056+(0.0020000000000000018)*(p-300)/100):0.058)))))))))+((p<=0?0:(p<10?(0+(0.01425)*(p-0)/10):(p<25?(0.01425+(0.03135)*(p-10)/15):(p<50?(0.0456+(0.0114)*(p-25)/25):(p<100?(0.057+(0.008)*(p-50)/50):(p<110?(0.065+(0.0005000000000000004)*(p-100)/10):(p<200?(0.0655+(0.004500000000000004)*(p-110)/90):(p<300?(0.07+(0.002999999999999989)*(p-200)/100):(p<400?(0.073+(0.0030000000000000027)*(p-300)/100):0.076)))))))))-(p<=0?0:(p<10?(0+(0.01025)*(p-0)/10):(p<25?(0.01025+(0.02255)*(p-10)/15):(p<50?(0.0328+(0.008199999999999999)*(p-25)/25):(p<100?(0.041+(0.007229999999999993)*(p-50)/50):(p<110?(0.048229999999999995+(0.0007700000000000068)*(p-100)/10):(p<200?(0.049+(0.003999999999999997)*(p-110)/90):(p<300?(0.053+(0.0030000000000000027)*(p-200)/100):(p<400?(0.056+(0.0020000000000000018)*(p-300)/100):0.058))))))))))*(g-(-7.5))/1.5):(g<-4?((p<=0?0:(p<10?(0+(0.01425)*(p-0)/10):(p<25?(0.01425+(0.03135)*(p-10)/15):(p<50?(0.0456+(0.0114)*(p-25)/25):(p<100?(0.057+(0.008)*(p-50)/50):(p<110?(0.065+(0.0005000000000000004)*(p-100)/10):(p<200?(0.0655+(0.004500000000000004)*(p-110)/90):(p<300?(0.07+(0.002999999999999989)*(p-200)/100):(p<400?(0.073+(0.0030000000000000027)*(p-300)/100):0.076)))))))))+((p<=0?0:(p<10?(0+(0.01925)*(p-0)/10):(p<25?(0.01925+(0.04235)*(p-10)/15):(p<50?(0.0616+(0.015399999999999997)*(p-25)/25):(p<100?(0.077+(0.007000000000000006)*(p-50)/50):(p<110?(0.084+(0.0005000000000000004)*(p-100)/10):(p<200?(0.0845+(0.006499999999999992)*(p-110)/90):(p<300?(0.091+(0.0040000000000000036)*(p-200)/100):(p<400?(0.095+(0.0030000000000000027)*(p-300)/100):0.098)))))))))-(p<=0?0:(p<10?(0+(0.01425)*(p-0)/10):(p<25?(0.01425+(0.03135)*(p-10)/15):(p<50?(0.0456+(0.0114)*(p-25)/25):(p<100?(0.057+(0.008)*(p-50)/50):(p<110?(0.065+(0.0005000000000000004)*(p-100)/10):(p<200?(0.0655+(0.004500000000000004)*(p-110)/90):(p<300?(0.07+(0.002999999999999989)*(p-200)/100):(p<400?(0.073+(0.0030000000000000027)*(p-300)/100):0.076))))))))))*(g-(-6))/2):(g<-2?((p<=0?0:(p<10?(0+(0.01925)*(p-0)/10):(p<25?(0.01925+(0.04235)*(p-10)/15):(p<50?(0.0616+(0.015399999999999997)*(p-25)/25):(p<100?(0.077+(0.007000000000000006)*(p-50)/50):(p<110?(0.084+(0.0005000000000000004)*(p-100)/10):(p<200?(0.0845+(0.006499999999999992)*(p-110)/90):(p<300?(0.091+(0.0040000000000000036)*(p-200)/100):(p<400?(0.095+(0.0030000000000000027)*(p-300)/100):0.098)))))))))+((p<=0?0:(p<10?(0+(0.02525)*(p-0)/10):(p<25?(0.02525+(0.05555000000000001)*(p-10)/15):(p<50?(0.08080000000000001+(0.020199999999999996)*(p-25)/25):(p<100?(0.101+(0.007999999999999993)*(p-50)/50):(p<110?(0.109+(0.0005000000000000004)*(p-100)/10):(p<200?(0.1095+(0.009499999999999995)*(p-110)/90):(p<300?(0.119+(0.0050000000000000044)*(p-200)/100):(p<400?(0.124+(0.0030000000000000027)*(p-300)/100):0.127)))))))))-(p<=0?0:(p<10?(0+(0.01925)*(p-0)/10):(p<25?(0.01925+(0.04235)*(p-10)/15):(p<50?(0.0616+(0.015399999999999997)*(p-25)/25):(p<100?(0.077+(0.007000000000000006)*(p-50)/50):(p<110?(0.084+(0.0005000000000000004)*(p-100)/10):(p<200?(0.0845+(0.006499999999999992)*(p-110)/90):(p<300?(0.091+(0.0040000000000000036)*(p-200)/100):(p<400?(0.095+(0.0030000000000000027)*(p-300)/100):0.098))))))))))*(g-(-4))/2):(g<0?((p<=0?0:(p<10?(0+(0.02525)*(p-0)/10):(p<25?(0.02525+(0.05555000000000001)*(p-10)/15):(p<50?(0.08080000000000001+(0.020199999999999996)*(p-25)/25):(p<100?(0.101+(0.007999999999999993)*(p-50)/50):(p<110?(0.109+(0.0005000000000000004)*(p-100)/10):(p<200?(0.1095+(0.009499999999999995)*(p-110)/90):(p<300?(0.119+(0.0050000000000000044)*(p-200)/100):(p<400?(0.124+(0.0030000000000000027)*(p-300)/100):0.127)))))))))+((p<=0?0:(p<10?(0+(0.032)*(p-0)/10):(p<25?(0.032+(0.0704)*(p-10)/15):(p<50?(0.1024+(0.025599999999999998)*(p-25)/25):(p<100?(0.128+(0.008000000000000007)*(p-50)/50):(p<110?(0.136+(0.0005000000000000004)*(p-100)/10):(p<200?(0.1365+(0.00949999999999998)*(p-110)/90):(p<300?(0.146+(0.006000000000000005)*(p-200)/100):(p<400?(0.152+(0.0040000000000000036)*(p-300)/100):0.156)))))))))-(p<=0?0:(p<10?(0+(0.02525)*(p-0)/10):(p<25?(0.02525+(0.05555000000000001)*(p-10)/15):(p<50?(0.08080000000000001+(0.020199999999999996)*(p-25)/25):(p<100?(0.101+(0.007999999999999993)*(p-50)/50):(p<110?(0.109+(0.0005000000000000004)*(p-100)/10):(p<200?(0.1095+(0.009499999999999995)*(p-110)/90):(p<300?(0.119+(0.0050000000000000044)*(p-200)/100):(p<400?(0.124+(0.0030000000000000027)*(p-300)/100):0.127))))))))))*(g-(-2))/2):(g<2?((p<=0?0:(p<10?(0+(0.032)*(p-0)/10):(p<25?(0.032+(0.0704)*(p-10)/15):(p<50?(0.1024+(0.025599999999999998)*(p-25)/25):(p<100?(0.128+(0.008000000000000007)*(p-50)/50):(p<110?(0.136+(0.0005000000000000004)*(p-100)/10):(p<200?(0.1365+(0.00949999999999998)*(p-110)/90):(p<300?(0.146+(0.006000000000000005)*(p-200)/100):(p<400?(0.152+(0.0040000000000000036)*(p-300)/100):0.156)))))))))+((p<=0?0:(p<10?(0+(0.0385)*(p-0)/10):(p<25?(0.0385+(0.0847)*(p-10)/15):(p<50?(0.1232+(0.030799999999999994)*(p-25)/25):(p<100?(0.154+(0.01100000000000001)*(p-50)/50):(p<110?(0.165+(0.0005000000000000004)*(p-100)/10):(p<200?(0.1655+(0.010499999999999982)*(p-110)/90):(p<300?(0.176+(0.006000000000000005)*(p-200)/100):(p<400?(0.182+(0.0050000000000000044)*(p-300)/100):0.187)))))))))-(p<=0?0:(p<10?(0+(0.032)*(p-0)/10):(p<25?(0.032+(0.0704)*(p-10)/15):(p<50?(0.1024+(0.025599999999999998)*(p-25)/25):(p<100?(0.128+(0.008000000000000007)*(p-50)/50):(p<110?(0.136+(0.0005000000000000004)*(p-100)/10):(p<200?(0.1365+(0.00949999999999998)*(p-110)/90):(p<300?(0.146+(0.006000000000000005)*(p-200)/100):(p<400?(0.152+(0.0040000000000000036)*(p-300)/100):0.156))))))))))*(g-(0))/2):(g<4?((p<=0?0:(p<10?(0+(0.0385)*(p-0)/10):(p<25?(0.0385+(0.0847)*(p-10)/15):(p<50?(0.1232+(0.030799999999999994)*(p-25)/25):(p<100?(0.154+(0.01100000000000001)*(p-50)/50):(p<110?(0.165+(0.0005000000000000004)*(p-100)/10):(p<200?(0.1655+(0.010499999999999982)*(p-110)/90):(p<300?(0.176+(0.006000000000000005)*(p-200)/100):(p<400?(0.182+(0.0050000000000000044)*(p-300)/100):0.187)))))))))+((p<=0?0:(p<10?(0+(0.0455)*(p-0)/10):(p<25?(0.0455+(0.10010000000000001)*(p-10)/15):(p<50?(0.1456+(0.03639999999999999)*(p-25)/25):(p<100?(0.182+(0.01100000000000001)*(p-50)/50):(p<110?(0.193+(0.0005000000000000004)*(p-100)/10):(p<200?(0.1935+(0.011499999999999982)*(p-110)/90):(p<300?(0.205+(0.007000000000000006)*(p-200)/100):(p<400?(0.212+(0.0050000000000000044)*(p-300)/100):0.217)))))))))-(p<=0?0:(p<10?(0+(0.0385)*(p-0)/10):(p<25?(0.0385+(0.0847)*(p-10)/15):(p<50?(0.1232+(0.030799999999999994)*(p-25)/25):(p<100?(0.154+(0.01100000000000001)*(p-50)/50):(p<110?(0.165+(0.0005000000000000004)*(p-100)/10):(p<200?(0.1655+(0.010499999999999982)*(p-110)/90):(p<300?(0.176+(0.006000000000000005)*(p-200)/100):(p<400?(0.182+(0.0050000000000000044)*(p-300)/100):0.187))))))))))*(g-(2))/2):(g<6?((p<=0?0:(p<10?(0+(0.0455)*(p-0)/10):(p<25?(0.0455+(0.10010000000000001)*(p-10)/15):(p<50?(0.1456+(0.03639999999999999)*(p-25)/25):(p<100?(0.182+(0.01100000000000001)*(p-50)/50):(p<110?(0.193+(0.0005000000000000004)*(p-100)/10):(p<200?(0.1935+(0.011499999999999982)*(p-110)/90):(p<300?(0.205+(0.007000000000000006)*(p-200)/100):(p<400?(0.212+(0.0050000000000000044)*(p-300)/100):0.217)))))))))+((p<=0?0:(p<10?(0+(0.05275)*(p-0)/10):(p<25?(0.05275+(0.11605000000000001)*(p-10)/15):(p<50?(0.1688+(0.04219999999999999)*(p-25)/25):(p<100?(0.211+(0.01200000000000001)*(p-50)/50):(p<110?(0.223+(0.0005000000000000004)*(p-100)/10):(p<200?(0.2235+(0.01050000000000001)*(p-110)/90):(p<300?(0.234+(0.0069999999999999785)*(p-200)/100):(p<400?(0.241+(0.0050000000000000044)*(p-300)/100):0.246)))))))))-(p<=0?0:(p<10?(0+(0.0455)*(p-0)/10):(p<25?(0.0455+(0.10010000000000001)*(p-10)/15):(p<50?(0.1456+(0.03639999999999999)*(p-25)/25):(p<100?(0.182+(0.01100000000000001)*(p-50)/50):(p<110?(0.193+(0.0005000000000000004)*(p-100)/10):(p<200?(0.1935+(0.011499999999999982)*(p-110)/90):(p<300?(0.205+(0.007000000000000006)*(p-200)/100):(p<400?(0.212+(0.0050000000000000044)*(p-300)/100):0.217))))))))))*(g-(4))/2):(p<=0?0:(p<10?(0+(0.05275)*(p-0)/10):(p<25?(0.05275+(0.11605000000000001)*(p-10)/15):(p<50?(0.1688+(0.04219999999999999)*(p-25)/25):(p<100?(0.211+(0.01200000000000001)*(p-50)/50):(p<110?(0.223+(0.0005000000000000004)*(p-100)/10):(p<200?(0.2235+(0.01050000000000001)*(p-110)/90):(p<300?(0.234+(0.0069999999999999785)*(p-200)/100):(p<400?(0.241+(0.0050000000000000044)*(p-300)/100):0.246))))))))))))))))))))))}
.func OUTS(p,g) {(g<=-20?(p<=0?0:(p<10?(0+(0)*(p-0)/10):(p<25?(0+(0)*(p-10)/15):(p<50?(0+(0)*(p-25)/25):(p<100?(0+(0)*(p-50)/50):(p<110?(0+(0)*(p-100)/10):(p<200?(0+(0)*(p-110)/90):(p<300?(0+(0)*(p-200)/100):(p<400?(0+(0)*(p-300)/100):0))))))))):(g<-16?((p<=0?0:(p<10?(0+(0)*(p-0)/10):(p<25?(0+(0)*(p-10)/15):(p<50?(0+(0)*(p-25)/25):(p<100?(0+(0)*(p-50)/50):(p<110?(0+(0)*(p-100)/10):(p<200?(0+(0)*(p-110)/90):(p<300?(0+(0)*(p-200)/100):(p<400?(0+(0)*(p-300)/100):0)))))))))+((p<=0?0.0021551020408163268:(p<10?(0.0021551020408163268+(-0.0005387755102040821)*(p-0)/10):(p<25?(0.0016163265306122446+(-0.0007183673469387754)*(p-10)/15):(p<50?(0.0008979591836734693+(-0.0005387755102040815)*(p-25)/25):(p<100?(0.00035918367346938774+(-0.00016881632653061225)*(p-50)/50):(p<110?(0.0001903673469387755+(-0.000010775510204081624)*(p-100)/10):(p<200?(0.00017959183673469387+(-0.00008081632653061223)*(p-110)/90):(p<300?(0.00009877551020408164+(-0.00003053061224489796)*(p-200)/100):(p<400?(0.00006824489795918367+(-0.000014367346938775519)*(p-300)/100):0.000053877551020408154)))))))))-(p<=0?0:(p<10?(0+(0)*(p-0)/10):(p<25?(0+(0)*(p-10)/15):(p<50?(0+(0)*(p-25)/25):(p<100?(0+(0)*(p-50)/50):(p<110?(0+(0)*(p-100)/10):(p<200?(0+(0)*(p-110)/90):(p<300?(0+(0)*(p-200)/100):(p<400?(0+(0)*(p-300)/100):0))))))))))*(g-(-20))/4):(g<-12?((p<=0?0.0021551020408163268:(p<10?(0.0021551020408163268+(-0.0005387755102040821)*(p-0)/10):(p<25?(0.0016163265306122446+(-0.0007183673469387754)*(p-10)/15):(p<50?(0.0008979591836734693+(-0.0005387755102040815)*(p-25)/25):(p<100?(0.00035918367346938774+(-0.00016881632653061225)*(p-50)/50):(p<110?(0.0001903673469387755+(-0.000010775510204081624)*(p-100)/10):(p<200?(0.00017959183673469387+(-0.00008081632653061223)*(p-110)/90):(p<300?(0.00009877551020408164+(-0.00003053061224489796)*(p-200)/100):(p<400?(0.00006824489795918367+(-0.000014367346938775519)*(p-300)/100):0.000053877551020408154)))))))))+((p<=0?0.01714285714285714:(p<10?(0.01714285714285714+(-0.004285714285714285)*(p-0)/10):(p<25?(0.012857142857142855+(-0.0057142857142857125)*(p-10)/15):(p<50?(0.007142857142857143+(-0.004285714285714286)*(p-25)/25):(p<100?(0.0028571428571428567+(-0.0013428571428571424)*(p-50)/50):(p<110?(0.0015142857142857143+(-0.00008571428571428597)*(p-100)/10):(p<200?(0.0014285714285714284+(-0.0006428571428571426)*(p-110)/90):(p<300?(0.0007857142857142857+(-0.00024285714285714297)*(p-200)/100):(p<400?(0.0005428571428571428+(-0.00011428571428571428)*(p-300)/100):0.0004285714285714285)))))))))-(p<=0?0.0021551020408163268:(p<10?(0.0021551020408163268+(-0.0005387755102040821)*(p-0)/10):(p<25?(0.0016163265306122446+(-0.0007183673469387754)*(p-10)/15):(p<50?(0.0008979591836734693+(-0.0005387755102040815)*(p-25)/25):(p<100?(0.00035918367346938774+(-0.00016881632653061225)*(p-50)/50):(p<110?(0.0001903673469387755+(-0.000010775510204081624)*(p-100)/10):(p<200?(0.00017959183673469387+(-0.00008081632653061223)*(p-110)/90):(p<300?(0.00009877551020408164+(-0.00003053061224489796)*(p-200)/100):(p<400?(0.00006824489795918367+(-0.000014367346938775519)*(p-300)/100):0.000053877551020408154))))))))))*(g-(-16))/4):(g<-10?((p<=0?0.01714285714285714:(p<10?(0.01714285714285714+(-0.004285714285714285)*(p-0)/10):(p<25?(0.012857142857142855+(-0.0057142857142857125)*(p-10)/15):(p<50?(0.007142857142857143+(-0.004285714285714286)*(p-25)/25):(p<100?(0.0028571428571428567+(-0.0013428571428571424)*(p-50)/50):(p<110?(0.0015142857142857143+(-0.00008571428571428597)*(p-100)/10):(p<200?(0.0014285714285714284+(-0.0006428571428571426)*(p-110)/90):(p<300?(0.0007857142857142857+(-0.00024285714285714297)*(p-200)/100):(p<400?(0.0005428571428571428+(-0.00011428571428571428)*(p-300)/100):0.0004285714285714285)))))))))+((p<=0?0.02987755102040816:(p<10?(0.02987755102040816+(-0.007469387755102041)*(p-0)/10):(p<25?(0.02240816326530612+(-0.009959183673469388)*(p-10)/15):(p<50?(0.012448979591836731+(-0.007469387755102038)*(p-25)/25):(p<100?(0.004979591836734693+(-0.0023404081632653058)*(p-50)/50):(p<110?(0.0026391836734693873+(-0.00014938775510204075)*(p-100)/10):(p<200?(0.0024897959183673465+(-0.0011204081632653056)*(p-110)/90):(p<300?(0.001369387755102041+(-0.00042326530612244915)*(p-200)/100):(p<400?(0.0009461224489795918+(-0.0001991836734693878)*(p-300)/100):0.000746938775510204)))))))))-(p<=0?0.01714285714285714:(p<10?(0.01714285714285714+(-0.004285714285714285)*(p-0)/10):(p<25?(0.012857142857142855+(-0.0057142857142857125)*(p-10)/15):(p<50?(0.007142857142857143+(-0.004285714285714286)*(p-25)/25):(p<100?(0.0028571428571428567+(-0.0013428571428571424)*(p-50)/50):(p<110?(0.0015142857142857143+(-0.00008571428571428597)*(p-100)/10):(p<200?(0.0014285714285714284+(-0.0006428571428571426)*(p-110)/90):(p<300?(0.0007857142857142857+(-0.00024285714285714297)*(p-200)/100):(p<400?(0.0005428571428571428+(-0.00011428571428571428)*(p-300)/100):0.0004285714285714285))))))))))*(g-(-12))/2):(g<-8?((p<=0?0.02987755102040816:(p<10?(0.02987755102040816+(-0.007469387755102041)*(p-0)/10):(p<25?(0.02240816326530612+(-0.009959183673469388)*(p-10)/15):(p<50?(0.012448979591836731+(-0.007469387755102038)*(p-25)/25):(p<100?(0.004979591836734693+(-0.0023404081632653058)*(p-50)/50):(p<110?(0.0026391836734693873+(-0.00014938775510204075)*(p-100)/10):(p<200?(0.0024897959183673465+(-0.0011204081632653056)*(p-110)/90):(p<300?(0.001369387755102041+(-0.00042326530612244915)*(p-200)/100):(p<400?(0.0009461224489795918+(-0.0001991836734693878)*(p-300)/100):0.000746938775510204)))))))))+((p<=0?0.04457142857142857:(p<10?(0.04457142857142857+(-0.011142857142857142)*(p-0)/10):(p<25?(0.033428571428571426+(-0.014857142857142857)*(p-10)/15):(p<50?(0.01857142857142857+(-0.011142857142857142)*(p-25)/25):(p<100?(0.007428571428571428+(-0.0034914285714285707)*(p-50)/50):(p<110?(0.003937142857142857+(-0.00022285714285714313)*(p-100)/10):(p<200?(0.003714285714285714+(-0.001671428571428571)*(p-110)/90):(p<300?(0.0020428571428571427+(-0.0006314285714285714)*(p-200)/100):(p<400?(0.0014114285714285713+(-0.00029714285714285715)*(p-300)/100):0.0011142857142857141)))))))))-(p<=0?0.02987755102040816:(p<10?(0.02987755102040816+(-0.007469387755102041)*(p-0)/10):(p<25?(0.02240816326530612+(-0.009959183673469388)*(p-10)/15):(p<50?(0.012448979591836731+(-0.007469387755102038)*(p-25)/25):(p<100?(0.004979591836734693+(-0.0023404081632653058)*(p-50)/50):(p<110?(0.0026391836734693873+(-0.00014938775510204075)*(p-100)/10):(p<200?(0.0024897959183673465+(-0.0011204081632653056)*(p-110)/90):(p<300?(0.001369387755102041+(-0.00042326530612244915)*(p-200)/100):(p<400?(0.0009461224489795918+(-0.0001991836734693878)*(p-300)/100):0.000746938775510204))))))))))*(g-(-10))/2):(g<-7.5?((p<=0?0.04457142857142857:(p<10?(0.04457142857142857+(-0.011142857142857142)*(p-0)/10):(p<25?(0.033428571428571426+(-0.014857142857142857)*(p-10)/15):(p<50?(0.01857142857142857+(-0.011142857142857142)*(p-25)/25):(p<100?(0.007428571428571428+(-0.0034914285714285707)*(p-50)/50):(p<110?(0.003937142857142857+(-0.00022285714285714313)*(p-100)/10):(p<200?(0.003714285714285714+(-0.001671428571428571)*(p-110)/90):(p<300?(0.0020428571428571427+(-0.0006314285714285714)*(p-200)/100):(p<400?(0.0014114285714285713+(-0.00029714285714285715)*(p-300)/100):0.0011142857142857141)))))))))+((p<=0?0.047999999999999994:(p<10?(0.047999999999999994+(-0.012000000000000004)*(p-0)/10):(p<25?(0.03599999999999999+(-0.015999999999999993)*(p-10)/15):(p<50?(0.019999999999999997+(-0.011999999999999999)*(p-25)/25):(p<100?(0.007999999999999998+(-0.0037599999999999995)*(p-50)/50):(p<110?(0.004239999999999999+(-0.00023999999999999976)*(p-100)/10):(p<200?(0.003999999999999999+(-0.0017999999999999995)*(p-110)/90):(p<300?(0.0021999999999999997+(-0.0006799999999999998)*(p-200)/100):(p<400?(0.0015199999999999999+(-0.0003200000000000002)*(p-300)/100):0.0011999999999999997)))))))))-(p<=0?0.04457142857142857:(p<10?(0.04457142857142857+(-0.011142857142857142)*(p-0)/10):(p<25?(0.033428571428571426+(-0.014857142857142857)*(p-10)/15):(p<50?(0.01857142857142857+(-0.011142857142857142)*(p-25)/25):(p<100?(0.007428571428571428+(-0.0034914285714285707)*(p-50)/50):(p<110?(0.003937142857142857+(-0.00022285714285714313)*(p-100)/10):(p<200?(0.003714285714285714+(-0.001671428571428571)*(p-110)/90):(p<300?(0.0020428571428571427+(-0.0006314285714285714)*(p-200)/100):(p<400?(0.0014114285714285713+(-0.00029714285714285715)*(p-300)/100):0.0011142857142857141))))))))))*(g-(-8))/0.5):(g<-6?((p<=0?0.047999999999999994:(p<10?(0.047999999999999994+(-0.012000000000000004)*(p-0)/10):(p<25?(0.03599999999999999+(-0.015999999999999993)*(p-10)/15):(p<50?(0.019999999999999997+(-0.011999999999999999)*(p-25)/25):(p<100?(0.007999999999999998+(-0.0037599999999999995)*(p-50)/50):(p<110?(0.004239999999999999+(-0.00023999999999999976)*(p-100)/10):(p<200?(0.003999999999999999+(-0.0017999999999999995)*(p-110)/90):(p<300?(0.0021999999999999997+(-0.0006799999999999998)*(p-200)/100):(p<400?(0.0015199999999999999+(-0.0003200000000000002)*(p-300)/100):0.0011999999999999997)))))))))+((p<=0?0.06416326530612244:(p<10?(0.06416326530612244+(-0.016040816326530614)*(p-0)/10):(p<25?(0.04812244897959183+(-0.02138775510204081)*(p-10)/15):(p<50?(0.02673469387755102+(-0.01604081632653061)*(p-25)/25):(p<100?(0.010693877551020407+(-0.005026122448979592)*(p-50)/50):(p<110?(0.005667755102040815+(-0.0003208163265306114)*(p-100)/10):(p<200?(0.005346938775510204+(-0.0024061224489795915)*(p-110)/90):(p<300?(0.002940816326530612+(-0.0009089795918367349)*(p-200)/100):(p<400?(0.0020318367346938773+(-0.0004277551020408165)*(p-300)/100):0.0016040816326530608)))))))))-(p<=0?0.047999999999999994:(p<10?(0.047999999999999994+(-0.012000000000000004)*(p-0)/10):(p<25?(0.03599999999999999+(-0.015999999999999993)*(p-10)/15):(p<50?(0.019999999999999997+(-0.011999999999999999)*(p-25)/25):(p<100?(0.007999999999999998+(-0.0037599999999999995)*(p-50)/50):(p<110?(0.004239999999999999+(-0.00023999999999999976)*(p-100)/10):(p<200?(0.003999999999999999+(-0.0017999999999999995)*(p-110)/90):(p<300?(0.0021999999999999997+(-0.0006799999999999998)*(p-200)/100):(p<400?(0.0015199999999999999+(-0.0003200000000000002)*(p-300)/100):0.0011999999999999997))))))))))*(g-(-7.5))/1.5):(g<-4?((p<=0?0.06416326530612244:(p<10?(0.06416326530612244+(-0.016040816326530614)*(p-0)/10):(p<25?(0.04812244897959183+(-0.02138775510204081)*(p-10)/15):(p<50?(0.02673469387755102+(-0.01604081632653061)*(p-25)/25):(p<100?(0.010693877551020407+(-0.005026122448979592)*(p-50)/50):(p<110?(0.005667755102040815+(-0.0003208163265306114)*(p-100)/10):(p<200?(0.005346938775510204+(-0.0024061224489795915)*(p-110)/90):(p<300?(0.002940816326530612+(-0.0009089795918367349)*(p-200)/100):(p<400?(0.0020318367346938773+(-0.0004277551020408165)*(p-300)/100):0.0016040816326530608)))))))))+((p<=0?0.08277551020408162:(p<10?(0.08277551020408162+(-0.020693877551020402)*(p-0)/10):(p<25?(0.06208163265306122+(-0.027591836734693877)*(p-10)/15):(p<50?(0.034489795918367344+(-0.02069387755102041)*(p-25)/25):(p<100?(0.013795918367346937+(-0.00648408163265306)*(p-50)/50):(p<110?(0.007311836734693876+(-0.0004138775510204081)*(p-100)/10):(p<200?(0.006897959183673468+(-0.00310408163265306)*(p-110)/90):(p<300?(0.0037938775510204083+(-0.00117265306122449)*(p-200)/100):(p<400?(0.0026212244897959184+(-0.0005518367346938782)*(p-300)/100):0.00206938775510204)))))))))-(p<=0?0.06416326530612244:(p<10?(0.06416326530612244+(-0.016040816326530614)*(p-0)/10):(p<25?(0.04812244897959183+(-0.02138775510204081)*(p-10)/15):(p<50?(0.02673469387755102+(-0.01604081632653061)*(p-25)/25):(p<100?(0.010693877551020407+(-0.005026122448979592)*(p-50)/50):(p<110?(0.005667755102040815+(-0.0003208163265306114)*(p-100)/10):(p<200?(0.005346938775510204+(-0.0024061224489795915)*(p-110)/90):(p<300?(0.002940816326530612+(-0.0009089795918367349)*(p-200)/100):(p<400?(0.0020318367346938773+(-0.0004277551020408165)*(p-300)/100):0.0016040816326530608))))))))))*(g-(-6))/2):(g<-2?((p<=0?0.08277551020408162:(p<10?(0.08277551020408162+(-0.020693877551020402)*(p-0)/10):(p<25?(0.06208163265306122+(-0.027591836734693877)*(p-10)/15):(p<50?(0.034489795918367344+(-0.02069387755102041)*(p-25)/25):(p<100?(0.013795918367346937+(-0.00648408163265306)*(p-50)/50):(p<110?(0.007311836734693876+(-0.0004138775510204081)*(p-100)/10):(p<200?(0.006897959183673468+(-0.00310408163265306)*(p-110)/90):(p<300?(0.0037938775510204083+(-0.00117265306122449)*(p-200)/100):(p<400?(0.0026212244897959184+(-0.0005518367346938782)*(p-300)/100):0.00206938775510204)))))))))+((p<=0?0.10726530612244897:(p<10?(0.10726530612244897+(-0.026816326530612236)*(p-0)/10):(p<25?(0.08044897959183674+(-0.035755102040816326)*(p-10)/15):(p<50?(0.04469387755102041+(-0.026816326530612247)*(p-25)/25):(p<100?(0.017877551020408163+(-0.008402448979591838)*(p-50)/50):(p<110?(0.009475102040816325+(-0.0005363265306122435)*(p-100)/10):(p<200?(0.008938775510204082+(-0.004022448979591836)*(p-110)/90):(p<300?(0.0049163265306122455+(-0.0015195918367346948)*(p-200)/100):(p<400?(0.0033967346938775507+(-0.0007151020408163265)*(p-300)/100):0.0026816326530612242)))))))))-(p<=0?0.08277551020408162:(p<10?(0.08277551020408162+(-0.020693877551020402)*(p-0)/10):(p<25?(0.06208163265306122+(-0.027591836734693877)*(p-10)/15):(p<50?(0.034489795918367344+(-0.02069387755102041)*(p-25)/25):(p<100?(0.013795918367346937+(-0.00648408163265306)*(p-50)/50):(p<110?(0.007311836734693876+(-0.0004138775510204081)*(p-100)/10):(p<200?(0.006897959183673468+(-0.00310408163265306)*(p-110)/90):(p<300?(0.0037938775510204083+(-0.00117265306122449)*(p-200)/100):(p<400?(0.0026212244897959184+(-0.0005518367346938782)*(p-300)/100):0.00206938775510204))))))))))*(g-(-4))/2):(g<0?((p<=0?0.10726530612244897:(p<10?(0.10726530612244897+(-0.026816326530612236)*(p-0)/10):(p<25?(0.08044897959183674+(-0.035755102040816326)*(p-10)/15):(p<50?(0.04469387755102041+(-0.026816326530612247)*(p-25)/25):(p<100?(0.017877551020408163+(-0.008402448979591838)*(p-50)/50):(p<110?(0.009475102040816325+(-0.0005363265306122435)*(p-100)/10):(p<200?(0.008938775510204082+(-0.004022448979591836)*(p-110)/90):(p<300?(0.0049163265306122455+(-0.0015195918367346948)*(p-200)/100):(p<400?(0.0033967346938775507+(-0.0007151020408163265)*(p-300)/100):0.0026816326530612242)))))))))+((p<=0?0.13371428571428573:(p<10?(0.13371428571428573+(-0.033428571428571446)*(p-0)/10):(p<25?(0.10028571428571428+(-0.044571428571428574)*(p-10)/15):(p<50?(0.05571428571428571+(-0.033428571428571426)*(p-25)/25):(p<100?(0.022285714285714284+(-0.010474285714285712)*(p-50)/50):(p<110?(0.011811428571428572+(-0.0006685714285714298)*(p-100)/10):(p<200?(0.011142857142857142+(-0.0050142857142857124)*(p-110)/90):(p<300?(0.006128571428571429+(-0.0018942857142857155)*(p-200)/100):(p<400?(0.004234285714285714+(-0.0008914285714285712)*(p-300)/100):0.0033428571428571426)))))))))-(p<=0?0.10726530612244897:(p<10?(0.10726530612244897+(-0.026816326530612236)*(p-0)/10):(p<25?(0.08044897959183674+(-0.035755102040816326)*(p-10)/15):(p<50?(0.04469387755102041+(-0.026816326530612247)*(p-25)/25):(p<100?(0.017877551020408163+(-0.008402448979591838)*(p-50)/50):(p<110?(0.009475102040816325+(-0.0005363265306122435)*(p-100)/10):(p<200?(0.008938775510204082+(-0.004022448979591836)*(p-110)/90):(p<300?(0.0049163265306122455+(-0.0015195918367346948)*(p-200)/100):(p<400?(0.0033967346938775507+(-0.0007151020408163265)*(p-300)/100):0.0026816326530612242))))))))))*(g-(-2))/2):(g<2?((p<=0?0.13371428571428573:(p<10?(0.13371428571428573+(-0.033428571428571446)*(p-0)/10):(p<25?(0.10028571428571428+(-0.044571428571428574)*(p-10)/15):(p<50?(0.05571428571428571+(-0.033428571428571426)*(p-25)/25):(p<100?(0.022285714285714284+(-0.010474285714285712)*(p-50)/50):(p<110?(0.011811428571428572+(-0.0006685714285714298)*(p-100)/10):(p<200?(0.011142857142857142+(-0.0050142857142857124)*(p-110)/90):(p<300?(0.006128571428571429+(-0.0018942857142857155)*(p-200)/100):(p<400?(0.004234285714285714+(-0.0008914285714285712)*(p-300)/100):0.0033428571428571426)))))))))+((p<=0?0.16212244897959183:(p<10?(0.16212244897959183+(-0.04053061224489796)*(p-0)/10):(p<25?(0.12159183673469387+(-0.0540408163265306)*(p-10)/15):(p<50?(0.06755102040816327+(-0.040530612244897964)*(p-25)/25):(p<100?(0.027020408163265307+(-0.012699591836734693)*(p-50)/50):(p<110?(0.014320816326530613+(-0.00081061224489796)*(p-100)/10):(p<200?(0.013510204081632653+(-0.006079591836734693)*(p-110)/90):(p<300?(0.00743061224489796+(-0.0022967346938775517)*(p-200)/100):(p<400?(0.005133877551020408+(-0.0010808163265306134)*(p-300)/100):0.004053061224489795)))))))))-(p<=0?0.13371428571428573:(p<10?(0.13371428571428573+(-0.033428571428571446)*(p-0)/10):(p<25?(0.10028571428571428+(-0.044571428571428574)*(p-10)/15):(p<50?(0.05571428571428571+(-0.033428571428571426)*(p-25)/25):(p<100?(0.022285714285714284+(-0.010474285714285712)*(p-50)/50):(p<110?(0.011811428571428572+(-0.0006685714285714298)*(p-100)/10):(p<200?(0.011142857142857142+(-0.0050142857142857124)*(p-110)/90):(p<300?(0.006128571428571429+(-0.0018942857142857155)*(p-200)/100):(p<400?(0.004234285714285714+(-0.0008914285714285712)*(p-300)/100):0.0033428571428571426))))))))))*(g-(0))/2):(g<4?((p<=0?0.16212244897959183:(p<10?(0.16212244897959183+(-0.04053061224489796)*(p-0)/10):(p<25?(0.12159183673469387+(-0.0540408163265306)*(p-10)/15):(p<50?(0.06755102040816327+(-0.040530612244897964)*(p-25)/25):(p<100?(0.027020408163265307+(-0.012699591836734693)*(p-50)/50):(p<110?(0.014320816326530613+(-0.00081061224489796)*(p-100)/10):(p<200?(0.013510204081632653+(-0.006079591836734693)*(p-110)/90):(p<300?(0.00743061224489796+(-0.0022967346938775517)*(p-200)/100):(p<400?(0.005133877551020408+(-0.0010808163265306134)*(p-300)/100):0.004053061224489795)))))))))+((p<=0?0.18955102040816324:(p<10?(0.18955102040816324+(-0.047387755102040796)*(p-0)/10):(p<25?(0.14216326530612244+(-0.06318367346938776)*(p-10)/15):(p<50?(0.07897959183673468+(-0.04738775510204081)*(p-25)/25):(p<100?(0.03159183673469387+(-0.014848163265306118)*(p-50)/50):(p<110?(0.016743673469387755+(-0.0009477551020408183)*(p-100)/10):(p<200?(0.015795918367346937+(-0.0071081632653061215)*(p-110)/90):(p<300?(0.008687755102040815+(-0.002685306122448979)*(p-200)/100):(p<400?(0.006002448979591836+(-0.001263673469387755)*(p-300)/100):0.004738775510204081)))))))))-(p<=0?0.16212244897959183:(p<10?(0.16212244897959183+(-0.04053061224489796)*(p-0)/10):(p<25?(0.12159183673469387+(-0.0540408163265306)*(p-10)/15):(p<50?(0.06755102040816327+(-0.040530612244897964)*(p-25)/25):(p<100?(0.027020408163265307+(-0.012699591836734693)*(p-50)/50):(p<110?(0.014320816326530613+(-0.00081061224489796)*(p-100)/10):(p<200?(0.013510204081632653+(-0.006079591836734693)*(p-110)/90):(p<300?(0.00743061224489796+(-0.0022967346938775517)*(p-200)/100):(p<400?(0.005133877551020408+(-0.0010808163265306134)*(p-300)/100):0.004053061224489795))))))))))*(g-(2))/2):(g<6?((p<=0?0.18955102040816324:(p<10?(0.18955102040816324+(-0.047387755102040796)*(p-0)/10):(p<25?(0.14216326530612244+(-0.06318367346938776)*(p-10)/15):(p<50?(0.07897959183673468+(-0.04738775510204081)*(p-25)/25):(p<100?(0.03159183673469387+(-0.014848163265306118)*(p-50)/50):(p<110?(0.016743673469387755+(-0.0009477551020408183)*(p-100)/10):(p<200?(0.015795918367346937+(-0.0071081632653061215)*(p-110)/90):(p<300?(0.008687755102040815+(-0.002685306122448979)*(p-200)/100):(p<400?(0.006002448979591836+(-0.001263673469387755)*(p-300)/100):0.004738775510204081)))))))))+((p<=0?0.21893877551020405:(p<10?(0.21893877551020405+(-0.054734693877551005)*(p-0)/10):(p<25?(0.16420408163265304+(-0.07297959183673468)*(p-10)/15):(p<50?(0.09122448979591836+(-0.054734693877551026)*(p-25)/25):(p<100?(0.03648979591836734+(-0.017150204081632647)*(p-50)/50):(p<110?(0.01933959183673469+(-0.0010946938775510222)*(p-100)/10):(p<200?(0.01824489795918367+(-0.00821020408163265)*(p-110)/90):(p<300?(0.010034693877551019+(-0.003101632653061224)*(p-200)/100):(p<400?(0.006933061224489795+(-0.0014595918367346934)*(p-300)/100):0.005473469387755101)))))))))-(p<=0?0.18955102040816324:(p<10?(0.18955102040816324+(-0.047387755102040796)*(p-0)/10):(p<25?(0.14216326530612244+(-0.06318367346938776)*(p-10)/15):(p<50?(0.07897959183673468+(-0.04738775510204081)*(p-25)/25):(p<100?(0.03159183673469387+(-0.014848163265306118)*(p-50)/50):(p<110?(0.016743673469387755+(-0.0009477551020408183)*(p-100)/10):(p<200?(0.015795918367346937+(-0.0071081632653061215)*(p-110)/90):(p<300?(0.008687755102040815+(-0.002685306122448979)*(p-200)/100):(p<400?(0.006002448979591836+(-0.001263673469387755)*(p-300)/100):0.004738775510204081))))))))))*(g-(4))/2):(p<=0?0.21893877551020405:(p<10?(0.21893877551020405+(-0.054734693877551005)*(p-0)/10):(p<25?(0.16420408163265304+(-0.07297959183673468)*(p-10)/15):(p<50?(0.09122448979591836+(-0.054734693877551026)*(p-25)/25):(p<100?(0.03648979591836734+(-0.017150204081632647)*(p-50)/50):(p<110?(0.01933959183673469+(-0.0010946938775510222)*(p-100)/10):(p<200?(0.01824489795918367+(-0.00821020408163265)*(p-110)/90):(p<300?(0.010034693877551019+(-0.003101632653061224)*(p-200)/100):(p<400?(0.006933061224489795+(-0.0014595918367346934)*(p-300)/100):0.005473469387755101))))))))))))))))))))))}
.func Q(s) {max(s,1e-6)/110}
C25 N_BPLUS_FILT 0 2e-8
C15 H 0 2.5e-10
R16TOP H W 200000
R16BOT W 0 300000
R19 G 0 4700000
R21 N_BPLUS_FILT P 470000
BTRI P 0 I={1*TRI(max(V(P),0),V(G))}
BTRIG G 0 I={1e-7*exp(min(5,V(G)/0.2))}
R23 O 0 470000
R24 K 0 130
C22 K 0 2.5e-10
BOP T K I={1*(V(N_BPLUS_FILT,K)>0)*Q(V(N_BPLUS_FILT,K))^1.5*OUTP(max(V(T,K),0)/Q(V(N_BPLUS_FILT,K)),V(O,K)/Q(V(N_BPLUS_FILT,K)))}
BOS N_BPLUS_FILT K I={1*(V(N_BPLUS_FILT,K)>0)*Q(V(N_BPLUS_FILT,K))^1.5*OUTS(max(V(T,K),0)/Q(V(N_BPLUS_FILT,K)),V(O,K)/Q(V(N_BPLUS_FILT,K)))}
BOG O K I={0.0007*(V(N_BPLUS_FILT,K)>0)*max(V(O,K),0)^1.5}
R26 N_BPLUS_RECT X 200
L26 X T 5
BSPEAKER SPEAKER 0 V={V(X,T)/25}
C18 W G 1e-8
C20 P O 1e-8
RREF X T 2000
* Converter injection/substitute loads and winding parameters are declared assumptions. No RF tracking claim.
.func IFP(p,g) {(g<=-40?(p<=0?0:(p<10?(0+(0.00004)*(p-0)/10):(p<25?(0.00004+(0.00003800000000000001)*(p-10)/15):(p<50?(0.00007800000000000001+(0.000016999999999999993)*(p-25)/25):(p<100?(0.000095+(0.0000049999999999999996)*(p-50)/50):(p<250?(0.0001+(0.000009999999999999999)*(p-100)/150):0.00011)))))):(g<-30?((p<=0?0:(p<10?(0+(0.00004)*(p-0)/10):(p<25?(0.00004+(0.00003800000000000001)*(p-10)/15):(p<50?(0.00007800000000000001+(0.000016999999999999993)*(p-25)/25):(p<100?(0.000095+(0.0000049999999999999996)*(p-50)/50):(p<250?(0.0001+(0.000009999999999999999)*(p-100)/150):0.00011))))))+((p<=0?0:(p<10?(0+(0.0001)*(p-0)/10):(p<25?(0.0001+(0.00009500000000000002)*(p-10)/15):(p<50?(0.00019500000000000002+(0.000042499999999999976)*(p-25)/25):(p<100?(0.0002375+(0.000012500000000000006)*(p-50)/50):(p<250?(0.00025+(0.00002999999999999997)*(p-100)/150):0.00028))))))-(p<=0?0:(p<10?(0+(0.00004)*(p-0)/10):(p<25?(0.00004+(0.00003800000000000001)*(p-10)/15):(p<50?(0.00007800000000000001+(0.000016999999999999993)*(p-25)/25):(p<100?(0.000095+(0.0000049999999999999996)*(p-50)/50):(p<250?(0.0001+(0.000009999999999999999)*(p-100)/150):0.00011)))))))*(g-(-40))/10):(g<-25?((p<=0?0:(p<10?(0+(0.0001)*(p-0)/10):(p<25?(0.0001+(0.00009500000000000002)*(p-10)/15):(p<50?(0.00019500000000000002+(0.000042499999999999976)*(p-25)/25):(p<100?(0.0002375+(0.000012500000000000006)*(p-50)/50):(p<250?(0.00025+(0.00002999999999999997)*(p-100)/150):0.00028))))))+((p<=0?0:(p<10?(0+(0.00016)*(p-0)/10):(p<25?(0.00016+(0.00015200000000000004)*(p-10)/15):(p<50?(0.00031200000000000005+(0.00006799999999999997)*(p-25)/25):(p<100?(0.00038+(0.000019999999999999998)*(p-50)/50):(p<250?(0.0004+(0.000039999999999999996)*(p-100)/150):0.00044))))))-(p<=0?0:(p<10?(0+(0.0001)*(p-0)/10):(p<25?(0.0001+(0.00009500000000000002)*(p-10)/15):(p<50?(0.00019500000000000002+(0.000042499999999999976)*(p-25)/25):(p<100?(0.0002375+(0.000012500000000000006)*(p-50)/50):(p<250?(0.00025+(0.00002999999999999997)*(p-100)/150):0.00028)))))))*(g-(-30))/5):(g<-20?((p<=0?0:(p<10?(0+(0.00016)*(p-0)/10):(p<25?(0.00016+(0.00015200000000000004)*(p-10)/15):(p<50?(0.00031200000000000005+(0.00006799999999999997)*(p-25)/25):(p<100?(0.00038+(0.000019999999999999998)*(p-50)/50):(p<250?(0.0004+(0.000039999999999999996)*(p-100)/150):0.00044))))))+((p<=0?0:(p<10?(0+(0.00026)*(p-0)/10):(p<25?(0.00026+(0.000247)*(p-10)/15):(p<50?(0.000507+(0.00011050000000000003)*(p-25)/25):(p<100?(0.0006175+(0.00003249999999999998)*(p-50)/50):(p<250?(0.00065+(0.00005000000000000002)*(p-100)/150):0.0007))))))-(p<=0?0:(p<10?(0+(0.00016)*(p-0)/10):(p<25?(0.00016+(0.00015200000000000004)*(p-10)/15):(p<50?(0.00031200000000000005+(0.00006799999999999997)*(p-25)/25):(p<100?(0.00038+(0.000019999999999999998)*(p-50)/50):(p<250?(0.0004+(0.000039999999999999996)*(p-100)/150):0.00044)))))))*(g-(-25))/5):(g<-15?((p<=0?0:(p<10?(0+(0.00026)*(p-0)/10):(p<25?(0.00026+(0.000247)*(p-10)/15):(p<50?(0.000507+(0.00011050000000000003)*(p-25)/25):(p<100?(0.0006175+(0.00003249999999999998)*(p-50)/50):(p<250?(0.00065+(0.00005000000000000002)*(p-100)/150):0.0007))))))+((p<=0?0:(p<10?(0+(0.00044000000000000007)*(p-0)/10):(p<25?(0.00044000000000000007+(0.00041799999999999997)*(p-10)/15):(p<50?(0.000858+(0.00018699999999999988)*(p-25)/25):(p<100?(0.001045+(0.000055000000000000144)*(p-50)/50):(p<250?(0.0011+(0.00009999999999999983)*(p-100)/150):0.0012))))))-(p<=0?0:(p<10?(0+(0.00026)*(p-0)/10):(p<25?(0.00026+(0.000247)*(p-10)/15):(p<50?(0.000507+(0.00011050000000000003)*(p-25)/25):(p<100?(0.0006175+(0.00003249999999999998)*(p-50)/50):(p<250?(0.00065+(0.00005000000000000002)*(p-100)/150):0.0007)))))))*(g-(-20))/5):(g<-12?((p<=0?0:(p<10?(0+(0.00044000000000000007)*(p-0)/10):(p<25?(0.00044000000000000007+(0.00041799999999999997)*(p-10)/15):(p<50?(0.000858+(0.00018699999999999988)*(p-25)/25):(p<100?(0.001045+(0.000055000000000000144)*(p-50)/50):(p<250?(0.0011+(0.00009999999999999983)*(p-100)/150):0.0012))))))+((p<=0?0:(p<10?(0+(0.00066)*(p-0)/10):(p<25?(0.00066+(0.000627)*(p-10)/15):(p<50?(0.001287+(0.00028049999999999993)*(p-25)/25):(p<100?(0.0015674999999999999+(0.00008250000000000011)*(p-50)/50):(p<250?(0.00165+(0.00014999999999999996)*(p-100)/150):0.0018))))))-(p<=0?0:(p<10?(0+(0.00044000000000000007)*(p-0)/10):(p<25?(0.00044000000000000007+(0.00041799999999999997)*(p-10)/15):(p<50?(0.000858+(0.00018699999999999988)*(p-25)/25):(p<100?(0.001045+(0.000055000000000000144)*(p-50)/50):(p<250?(0.0011+(0.00009999999999999983)*(p-100)/150):0.0012)))))))*(g-(-15))/3):(g<-10.5?((p<=0?0:(p<10?(0+(0.00066)*(p-0)/10):(p<25?(0.00066+(0.000627)*(p-10)/15):(p<50?(0.001287+(0.00028049999999999993)*(p-25)/25):(p<100?(0.0015674999999999999+(0.00008250000000000011)*(p-50)/50):(p<250?(0.00165+(0.00014999999999999996)*(p-100)/150):0.0018))))))+((p<=0?0:(p<10?(0+(0.0008200000000000001)*(p-0)/10):(p<25?(0.0008200000000000001+(0.0007790000000000001)*(p-10)/15):(p<50?(0.0015990000000000002+(0.00034849999999999985)*(p-25)/25):(p<100?(0.0019475+(0.00010250000000000016)*(p-50)/50):(p<250?(0.00205+(0.00014999999999999996)*(p-100)/150):0.0022))))))-(p<=0?0:(p<10?(0+(0.00066)*(p-0)/10):(p<25?(0.00066+(0.000627)*(p-10)/15):(p<50?(0.001287+(0.00028049999999999993)*(p-25)/25):(p<100?(0.0015674999999999999+(0.00008250000000000011)*(p-50)/50):(p<250?(0.00165+(0.00014999999999999996)*(p-100)/150):0.0018)))))))*(g-(-12))/1.5):(g<-9?((p<=0?0:(p<10?(0+(0.0008200000000000001)*(p-0)/10):(p<25?(0.0008200000000000001+(0.0007790000000000001)*(p-10)/15):(p<50?(0.0015990000000000002+(0.00034849999999999985)*(p-25)/25):(p<100?(0.0019475+(0.00010250000000000016)*(p-50)/50):(p<250?(0.00205+(0.00014999999999999996)*(p-100)/150):0.0022))))))+((p<=0?0:(p<10?(0+(0.00104)*(p-0)/10):(p<25?(0.00104+(0.000988)*(p-10)/15):(p<50?(0.002028+(0.0004420000000000001)*(p-25)/25):(p<100?(0.00247+(0.0001299999999999999)*(p-50)/50):(p<250?(0.0026+(0.0002000000000000001)*(p-100)/150):0.0028))))))-(p<=0?0:(p<10?(0+(0.0008200000000000001)*(p-0)/10):(p<25?(0.0008200000000000001+(0.0007790000000000001)*(p-10)/15):(p<50?(0.0015990000000000002+(0.00034849999999999985)*(p-25)/25):(p<100?(0.0019475+(0.00010250000000000016)*(p-50)/50):(p<250?(0.00205+(0.00014999999999999996)*(p-100)/150):0.0022)))))))*(g-(-10.5))/1.5):(g<-7.5?((p<=0?0:(p<10?(0+(0.00104)*(p-0)/10):(p<25?(0.00104+(0.000988)*(p-10)/15):(p<50?(0.002028+(0.0004420000000000001)*(p-25)/25):(p<100?(0.00247+(0.0001299999999999999)*(p-50)/50):(p<250?(0.0026+(0.0002000000000000001)*(p-100)/150):0.0028))))))+((p<=0?0:(p<10?(0+(0.00136)*(p-0)/10):(p<25?(0.00136+(0.0012919999999999997)*(p-10)/15):(p<50?(0.002652+(0.000578)*(p-25)/25):(p<100?(0.00323+(0.00017)*(p-50)/50):(p<250?(0.0034+(0.00030000000000000035)*(p-100)/150):0.0037))))))-(p<=0?0:(p<10?(0+(0.00104)*(p-0)/10):(p<25?(0.00104+(0.000988)*(p-10)/15):(p<50?(0.002028+(0.0004420000000000001)*(p-25)/25):(p<100?(0.00247+(0.0001299999999999999)*(p-50)/50):(p<250?(0.0026+(0.0002000000000000001)*(p-100)/150):0.0028)))))))*(g-(-9))/1.5):(g<-6?((p<=0?0:(p<10?(0+(0.00136)*(p-0)/10):(p<25?(0.00136+(0.0012919999999999997)*(p-10)/15):(p<50?(0.002652+(0.000578)*(p-25)/25):(p<100?(0.00323+(0.00017)*(p-50)/50):(p<250?(0.0034+(0.00030000000000000035)*(p-100)/150):0.0037))))))+((p<=0?0:(p<10?(0+(0.00184)*(p-0)/10):(p<25?(0.00184+(0.001748)*(p-10)/15):(p<50?(0.003588+(0.0007819999999999997)*(p-25)/25):(p<100?(0.00437+(0.00023000000000000017)*(p-50)/50):(p<250?(0.0046+(0.0002999999999999999)*(p-100)/150):0.0049))))))-(p<=0?0:(p<10?(0+(0.00136)*(p-0)/10):(p<25?(0.00136+(0.0012919999999999997)*(p-10)/15):(p<50?(0.002652+(0.000578)*(p-25)/25):(p<100?(0.00323+(0.00017)*(p-50)/50):(p<250?(0.0034+(0.00030000000000000035)*(p-100)/150):0.0037)))))))*(g-(-7.5))/1.5):(g<-4.5?((p<=0?0:(p<10?(0+(0.00184)*(p-0)/10):(p<25?(0.00184+(0.001748)*(p-10)/15):(p<50?(0.003588+(0.0007819999999999997)*(p-25)/25):(p<100?(0.00437+(0.00023000000000000017)*(p-50)/50):(p<250?(0.0046+(0.0002999999999999999)*(p-100)/150):0.0049))))))+((p<=0?0:(p<10?(0+(0.0024400000000000003)*(p-0)/10):(p<25?(0.0024400000000000003+(0.0023179999999999997)*(p-10)/15):(p<50?(0.004758+(0.0010369999999999997)*(p-25)/25):(p<100?(0.005795+(0.0003050000000000006)*(p-50)/50):(p<250?(0.0061+(0.0002999999999999999)*(p-100)/150):0.0064))))))-(p<=0?0:(p<10?(0+(0.00184)*(p-0)/10):(p<25?(0.00184+(0.001748)*(p-10)/15):(p<50?(0.003588+(0.0007819999999999997)*(p-25)/25):(p<100?(0.00437+(0.00023000000000000017)*(p-50)/50):(p<250?(0.0046+(0.0002999999999999999)*(p-100)/150):0.0049)))))))*(g-(-6))/1.5):(g<-3?((p<=0?0:(p<10?(0+(0.0024400000000000003)*(p-0)/10):(p<25?(0.0024400000000000003+(0.0023179999999999997)*(p-10)/15):(p<50?(0.004758+(0.0010369999999999997)*(p-25)/25):(p<100?(0.005795+(0.0003050000000000006)*(p-50)/50):(p<250?(0.0061+(0.0002999999999999999)*(p-100)/150):0.0064))))))+((p<=0?0:(p<10?(0+(0.0032800000000000004)*(p-0)/10):(p<25?(0.0032800000000000004+(0.0031160000000000003)*(p-10)/15):(p<50?(0.006396000000000001+(0.0013939999999999994)*(p-25)/25):(p<100?(0.00779+(0.00041000000000000064)*(p-50)/50):(p<250?(0.0082+(0.0002999999999999999)*(p-100)/150):0.0085))))))-(p<=0?0:(p<10?(0+(0.0024400000000000003)*(p-0)/10):(p<25?(0.0024400000000000003+(0.0023179999999999997)*(p-10)/15):(p<50?(0.004758+(0.0010369999999999997)*(p-25)/25):(p<100?(0.005795+(0.0003050000000000006)*(p-50)/50):(p<250?(0.0061+(0.0002999999999999999)*(p-100)/150):0.0064)))))))*(g-(-4.5))/1.5):(g<-1.5?((p<=0?0:(p<10?(0+(0.0032800000000000004)*(p-0)/10):(p<25?(0.0032800000000000004+(0.0031160000000000003)*(p-10)/15):(p<50?(0.006396000000000001+(0.0013939999999999994)*(p-25)/25):(p<100?(0.00779+(0.00041000000000000064)*(p-50)/50):(p<250?(0.0082+(0.0002999999999999999)*(p-100)/150):0.0085))))))+((p<=0?0:(p<10?(0+(0.00432)*(p-0)/10):(p<25?(0.00432+(0.004104000000000001)*(p-10)/15):(p<50?(0.008424000000000001+(0.001835999999999999)*(p-25)/25):(p<100?(0.01026+(0.0005400000000000005)*(p-50)/50):(p<250?(0.0108+(0.0004999999999999987)*(p-100)/150):0.0113))))))-(p<=0?0:(p<10?(0+(0.0032800000000000004)*(p-0)/10):(p<25?(0.0032800000000000004+(0.0031160000000000003)*(p-10)/15):(p<50?(0.006396000000000001+(0.0013939999999999994)*(p-25)/25):(p<100?(0.00779+(0.00041000000000000064)*(p-50)/50):(p<250?(0.0082+(0.0002999999999999999)*(p-100)/150):0.0085)))))))*(g-(-3))/1.5):(g<0?((p<=0?0:(p<10?(0+(0.00432)*(p-0)/10):(p<25?(0.00432+(0.004104000000000001)*(p-10)/15):(p<50?(0.008424000000000001+(0.001835999999999999)*(p-25)/25):(p<100?(0.01026+(0.0005400000000000005)*(p-50)/50):(p<250?(0.0108+(0.0004999999999999987)*(p-100)/150):0.0113))))))+((p<=0?0:(p<10?(0+(0.005520000000000001)*(p-0)/10):(p<25?(0.005520000000000001+(0.005244)*(p-10)/15):(p<50?(0.010764000000000001+(0.0023459999999999974)*(p-25)/25):(p<100?(0.013109999999999998+(0.0006900000000000014)*(p-50)/50):(p<250?(0.0138+(0.0005999999999999998)*(p-100)/150):0.0144))))))-(p<=0?0:(p<10?(0+(0.00432)*(p-0)/10):(p<25?(0.00432+(0.004104000000000001)*(p-10)/15):(p<50?(0.008424000000000001+(0.001835999999999999)*(p-25)/25):(p<100?(0.01026+(0.0005400000000000005)*(p-50)/50):(p<250?(0.0108+(0.0004999999999999987)*(p-100)/150):0.0113)))))))*(g-(-1.5))/1.5):(p<=0?0:(p<10?(0+(0.005520000000000001)*(p-0)/10):(p<25?(0.005520000000000001+(0.005244)*(p-10)/15):(p<50?(0.010764000000000001+(0.0023459999999999974)*(p-25)/25):(p<100?(0.013109999999999998+(0.0006900000000000014)*(p-50)/50):(p<250?(0.0138+(0.0005999999999999998)*(p-100)/150):0.0144))))))))))))))))))))}
.func IFS(p,g) {(g<=-40?(p<=0?0.00007500000000000001:(p<10?(0.00007500000000000001+(-0.000022500000000000005)*(p-0)/10):(p<25?(0.0000525+(-0.000018749999999999995)*(p-10)/15):(p<50?(0.00003375000000000001+(-0.000006750000000000005)*(p-25)/25):(p<100?(0.000027000000000000002+(-0.000002000000000000001)*(p-50)/50):(p<250?(0.000025+(-0.0000013888888888888906)*(p-100)/150):0.00002361111111111111)))))):(g<-30?((p<=0?0.00007500000000000001:(p<10?(0.00007500000000000001+(-0.000022500000000000005)*(p-0)/10):(p<25?(0.0000525+(-0.000018749999999999995)*(p-10)/15):(p<50?(0.00003375000000000001+(-0.000006750000000000005)*(p-25)/25):(p<100?(0.000027000000000000002+(-0.000002000000000000001)*(p-50)/50):(p<250?(0.000025+(-0.0000013888888888888906)*(p-100)/150):0.00002361111111111111))))))+((p<=0?0.00018:(p<10?(0.00018+(-0.00005400000000000001)*(p-0)/10):(p<25?(0.000126+(-0.000044999999999999996)*(p-10)/15):(p<50?(0.000081+(-0.0000162)*(p-25)/25):(p<100?(0.0000648+(-0.0000048000000000000015)*(p-50)/50):(p<250?(0.00006+(-0.0000033333333333333376)*(p-100)/150):0.000056666666666666664))))))-(p<=0?0.00007500000000000001:(p<10?(0.00007500000000000001+(-0.000022500000000000005)*(p-0)/10):(p<25?(0.0000525+(-0.000018749999999999995)*(p-10)/15):(p<50?(0.00003375000000000001+(-0.000006750000000000005)*(p-25)/25):(p<100?(0.000027000000000000002+(-0.000002000000000000001)*(p-50)/50):(p<250?(0.000025+(-0.0000013888888888888906)*(p-100)/150):0.00002361111111111111)))))))*(g-(-40))/10):(g<-25?((p<=0?0.00018:(p<10?(0.00018+(-0.00005400000000000001)*(p-0)/10):(p<25?(0.000126+(-0.000044999999999999996)*(p-10)/15):(p<50?(0.000081+(-0.0000162)*(p-25)/25):(p<100?(0.0000648+(-0.0000048000000000000015)*(p-50)/50):(p<250?(0.00006+(-0.0000033333333333333376)*(p-100)/150):0.000056666666666666664))))))+((p<=0?0.00027:(p<10?(0.00027+(-0.00008099999999999999)*(p-0)/10):(p<25?(0.000189+(-0.0000675)*(p-10)/15):(p<50?(0.00012150000000000001+(-0.000024299999999999994)*(p-25)/25):(p<100?(0.00009720000000000002+(-0.000007200000000000012)*(p-50)/50):(p<250?(0.00009+(-0.0000049999999999999996)*(p-100)/150):0.000085))))))-(p<=0?0.00018:(p<10?(0.00018+(-0.00005400000000000001)*(p-0)/10):(p<25?(0.000126+(-0.000044999999999999996)*(p-10)/15):(p<50?(0.000081+(-0.0000162)*(p-25)/25):(p<100?(0.0000648+(-0.0000048000000000000015)*(p-50)/50):(p<250?(0.00006+(-0.0000033333333333333376)*(p-100)/150):0.000056666666666666664)))))))*(g-(-30))/5):(g<-20?((p<=0?0.00027:(p<10?(0.00027+(-0.00008099999999999999)*(p-0)/10):(p<25?(0.000189+(-0.0000675)*(p-10)/15):(p<50?(0.00012150000000000001+(-0.000024299999999999994)*(p-25)/25):(p<100?(0.00009720000000000002+(-0.000007200000000000012)*(p-50)/50):(p<250?(0.00009+(-0.0000049999999999999996)*(p-100)/150):0.000085))))))+((p<=0?0.00041999999999999996:(p<10?(0.00041999999999999996+(-0.00012599999999999997)*(p-0)/10):(p<25?(0.000294+(-0.000105)*(p-10)/15):(p<50?(0.00018899999999999999+(-0.0000378)*(p-25)/25):(p<100?(0.0001512+(-0.000011200000000000001)*(p-50)/50):(p<250?(0.00014+(-0.000007777777777777774)*(p-100)/150):0.00013222222222222221))))))-(p<=0?0.00027:(p<10?(0.00027+(-0.00008099999999999999)*(p-0)/10):(p<25?(0.000189+(-0.0000675)*(p-10)/15):(p<50?(0.00012150000000000001+(-0.000024299999999999994)*(p-25)/25):(p<100?(0.00009720000000000002+(-0.000007200000000000012)*(p-50)/50):(p<250?(0.00009+(-0.0000049999999999999996)*(p-100)/150):0.000085)))))))*(g-(-25))/5):(g<-15?((p<=0?0.00041999999999999996:(p<10?(0.00041999999999999996+(-0.00012599999999999997)*(p-0)/10):(p<25?(0.000294+(-0.000105)*(p-10)/15):(p<50?(0.00018899999999999999+(-0.0000378)*(p-25)/25):(p<100?(0.0001512+(-0.000011200000000000001)*(p-50)/50):(p<250?(0.00014+(-0.000007777777777777774)*(p-100)/150):0.00013222222222222221))))))+((p<=0?0.00072:(p<10?(0.00072+(-0.00021600000000000005)*(p-0)/10):(p<25?(0.000504+(-0.00017999999999999998)*(p-10)/15):(p<50?(0.000324+(-0.0000648)*(p-25)/25):(p<100?(0.0002592+(-0.000019200000000000006)*(p-50)/50):(p<250?(0.00024+(-0.00001333333333333335)*(p-100)/150):0.00022666666666666666))))))-(p<=0?0.00041999999999999996:(p<10?(0.00041999999999999996+(-0.00012599999999999997)*(p-0)/10):(p<25?(0.000294+(-0.000105)*(p-10)/15):(p<50?(0.00018899999999999999+(-0.0000378)*(p-25)/25):(p<100?(0.0001512+(-0.000011200000000000001)*(p-50)/50):(p<250?(0.00014+(-0.000007777777777777774)*(p-100)/150):0.00013222222222222221)))))))*(g-(-20))/5):(g<-12?((p<=0?0.00072:(p<10?(0.00072+(-0.00021600000000000005)*(p-0)/10):(p<25?(0.000504+(-0.00017999999999999998)*(p-10)/15):(p<50?(0.000324+(-0.0000648)*(p-25)/25):(p<100?(0.0002592+(-0.000019200000000000006)*(p-50)/50):(p<250?(0.00024+(-0.00001333333333333335)*(p-100)/150):0.00022666666666666666))))))+((p<=0?0.00108:(p<10?(0.00108+(-0.00032399999999999996)*(p-0)/10):(p<25?(0.000756+(-0.00027)*(p-10)/15):(p<50?(0.00048600000000000005+(-0.00009719999999999998)*(p-25)/25):(p<100?(0.00038880000000000007+(-0.00002880000000000005)*(p-50)/50):(p<250?(0.00036+(-0.000019999999999999998)*(p-100)/150):0.00034))))))-(p<=0?0.00072:(p<10?(0.00072+(-0.00021600000000000005)*(p-0)/10):(p<25?(0.000504+(-0.00017999999999999998)*(p-10)/15):(p<50?(0.000324+(-0.0000648)*(p-25)/25):(p<100?(0.0002592+(-0.000019200000000000006)*(p-50)/50):(p<250?(0.00024+(-0.00001333333333333335)*(p-100)/150):0.00022666666666666666)))))))*(g-(-15))/3):(g<-10.5?((p<=0?0.00108:(p<10?(0.00108+(-0.00032399999999999996)*(p-0)/10):(p<25?(0.000756+(-0.00027)*(p-10)/15):(p<50?(0.00048600000000000005+(-0.00009719999999999998)*(p-25)/25):(p<100?(0.00038880000000000007+(-0.00002880000000000005)*(p-50)/50):(p<250?(0.00036+(-0.000019999999999999998)*(p-100)/150):0.00034))))))+((p<=0?0.00132:(p<10?(0.00132+(-0.00039599999999999987)*(p-0)/10):(p<25?(0.0009240000000000001+(-0.0003300000000000001)*(p-10)/15):(p<50?(0.000594+(-0.00011879999999999996)*(p-25)/25):(p<100?(0.00047520000000000006+(-0.00003520000000000004)*(p-50)/50):(p<250?(0.00044+(-0.00002444444444444445)*(p-100)/150):0.00041555555555555557))))))-(p<=0?0.00108:(p<10?(0.00108+(-0.00032399999999999996)*(p-0)/10):(p<25?(0.000756+(-0.00027)*(p-10)/15):(p<50?(0.00048600000000000005+(-0.00009719999999999998)*(p-25)/25):(p<100?(0.00038880000000000007+(-0.00002880000000000005)*(p-50)/50):(p<250?(0.00036+(-0.000019999999999999998)*(p-100)/150):0.00034)))))))*(g-(-12))/1.5):(g<-9?((p<=0?0.00132:(p<10?(0.00132+(-0.00039599999999999987)*(p-0)/10):(p<25?(0.0009240000000000001+(-0.0003300000000000001)*(p-10)/15):(p<50?(0.000594+(-0.00011879999999999996)*(p-25)/25):(p<100?(0.00047520000000000006+(-0.00003520000000000004)*(p-50)/50):(p<250?(0.00044+(-0.00002444444444444445)*(p-100)/150):0.00041555555555555557))))))+((p<=0?0.0016799999999999999:(p<10?(0.0016799999999999999+(-0.0005039999999999999)*(p-0)/10):(p<25?(0.001176+(-0.00042)*(p-10)/15):(p<50?(0.0007559999999999999+(-0.0001512)*(p-25)/25):(p<100?(0.0006048+(-0.000044800000000000005)*(p-50)/50):(p<250?(0.00056+(-0.000031111111111111096)*(p-100)/150):0.0005288888888888889))))))-(p<=0?0.00132:(p<10?(0.00132+(-0.00039599999999999987)*(p-0)/10):(p<25?(0.0009240000000000001+(-0.0003300000000000001)*(p-10)/15):(p<50?(0.000594+(-0.00011879999999999996)*(p-25)/25):(p<100?(0.00047520000000000006+(-0.00003520000000000004)*(p-50)/50):(p<250?(0.00044+(-0.00002444444444444445)*(p-100)/150):0.00041555555555555557)))))))*(g-(-10.5))/1.5):(g<-7.5?((p<=0?0.0016799999999999999:(p<10?(0.0016799999999999999+(-0.0005039999999999999)*(p-0)/10):(p<25?(0.001176+(-0.00042)*(p-10)/15):(p<50?(0.0007559999999999999+(-0.0001512)*(p-25)/25):(p<100?(0.0006048+(-0.000044800000000000005)*(p-50)/50):(p<250?(0.00056+(-0.000031111111111111096)*(p-100)/150):0.0005288888888888889))))))+((p<=0?0.00219:(p<10?(0.00219+(-0.000657)*(p-0)/10):(p<25?(0.001533+(-0.0005475)*(p-10)/15):(p<50?(0.0009855+(-0.00019710000000000007)*(p-25)/25):(p<100?(0.0007884+(-0.00005840000000000001)*(p-50)/50):(p<250?(0.00073+(-0.000040555555555555614)*(p-100)/150):0.0006894444444444443))))))-(p<=0?0.0016799999999999999:(p<10?(0.0016799999999999999+(-0.0005039999999999999)*(p-0)/10):(p<25?(0.001176+(-0.00042)*(p-10)/15):(p<50?(0.0007559999999999999+(-0.0001512)*(p-25)/25):(p<100?(0.0006048+(-0.000044800000000000005)*(p-50)/50):(p<250?(0.00056+(-0.000031111111111111096)*(p-100)/150):0.0005288888888888889)))))))*(g-(-9))/1.5):(g<-6?((p<=0?0.00219:(p<10?(0.00219+(-0.000657)*(p-0)/10):(p<25?(0.001533+(-0.0005475)*(p-10)/15):(p<50?(0.0009855+(-0.00019710000000000007)*(p-25)/25):(p<100?(0.0007884+(-0.00005840000000000001)*(p-50)/50):(p<250?(0.00073+(-0.000040555555555555614)*(p-100)/150):0.0006894444444444443))))))+((p<=0?0.003:(p<10?(0.003+(-0.0008999999999999998)*(p-0)/10):(p<25?(0.0021000000000000003+(-0.0007500000000000002)*(p-10)/15):(p<50?(0.00135+(-0.00027000000000000006)*(p-25)/25):(p<100?(0.00108+(-0.00007999999999999999)*(p-50)/50):(p<250?(0.001+(-0.000055555555555555545)*(p-100)/150):0.0009444444444444445))))))-(p<=0?0.00219:(p<10?(0.00219+(-0.000657)*(p-0)/10):(p<25?(0.001533+(-0.0005475)*(p-10)/15):(p<50?(0.0009855+(-0.00019710000000000007)*(p-25)/25):(p<100?(0.0007884+(-0.00005840000000000001)*(p-50)/50):(p<250?(0.00073+(-0.000040555555555555614)*(p-100)/150):0.0006894444444444443)))))))*(g-(-7.5))/1.5):(g<-4.5?((p<=0?0.003:(p<10?(0.003+(-0.0008999999999999998)*(p-0)/10):(p<25?(0.0021000000000000003+(-0.0007500000000000002)*(p-10)/15):(p<50?(0.00135+(-0.00027000000000000006)*(p-25)/25):(p<100?(0.00108+(-0.00007999999999999999)*(p-50)/50):(p<250?(0.001+(-0.000055555555555555545)*(p-100)/150):0.0009444444444444445))))))+((p<=0?0.0039900000000000005:(p<10?(0.0039900000000000005+(-0.0011970000000000001)*(p-0)/10):(p<25?(0.0027930000000000003+(-0.0009975000000000001)*(p-10)/15):(p<50?(0.0017955000000000002+(-0.0003591)*(p-25)/25):(p<100?(0.0014364000000000002+(-0.0001064000000000002)*(p-50)/50):(p<250?(0.00133+(-0.00007388888888888896)*(p-100)/150):0.001256111111111111))))))-(p<=0?0.003:(p<10?(0.003+(-0.0008999999999999998)*(p-0)/10):(p<25?(0.0021000000000000003+(-0.0007500000000000002)*(p-10)/15):(p<50?(0.00135+(-0.00027000000000000006)*(p-25)/25):(p<100?(0.00108+(-0.00007999999999999999)*(p-50)/50):(p<250?(0.001+(-0.000055555555555555545)*(p-100)/150):0.0009444444444444445)))))))*(g-(-6))/1.5):(g<-3?((p<=0?0.0039900000000000005:(p<10?(0.0039900000000000005+(-0.0011970000000000001)*(p-0)/10):(p<25?(0.0027930000000000003+(-0.0009975000000000001)*(p-10)/15):(p<50?(0.0017955000000000002+(-0.0003591)*(p-25)/25):(p<100?(0.0014364000000000002+(-0.0001064000000000002)*(p-50)/50):(p<250?(0.00133+(-0.00007388888888888896)*(p-100)/150):0.001256111111111111))))))+((p<=0?0.0054:(p<10?(0.0054+(-0.0016200000000000003)*(p-0)/10):(p<25?(0.00378+(-0.0013499999999999996)*(p-10)/15):(p<50?(0.0024300000000000003+(-0.0004860000000000003)*(p-25)/25):(p<100?(0.001944+(-0.00014400000000000003)*(p-50)/50):(p<250?(0.0018+(-0.00010000000000000005)*(p-100)/150):0.0017))))))-(p<=0?0.0039900000000000005:(p<10?(0.0039900000000000005+(-0.0011970000000000001)*(p-0)/10):(p<25?(0.0027930000000000003+(-0.0009975000000000001)*(p-10)/15):(p<50?(0.0017955000000000002+(-0.0003591)*(p-25)/25):(p<100?(0.0014364000000000002+(-0.0001064000000000002)*(p-50)/50):(p<250?(0.00133+(-0.00007388888888888896)*(p-100)/150):0.001256111111111111)))))))*(g-(-4.5))/1.5):(g<-1.5?((p<=0?0.0054:(p<10?(0.0054+(-0.0016200000000000003)*(p-0)/10):(p<25?(0.00378+(-0.0013499999999999996)*(p-10)/15):(p<50?(0.0024300000000000003+(-0.0004860000000000003)*(p-25)/25):(p<100?(0.001944+(-0.00014400000000000003)*(p-50)/50):(p<250?(0.0018+(-0.00010000000000000005)*(p-100)/150):0.0017))))))+((p<=0?0.0072:(p<10?(0.0072+(-0.0021600000000000005)*(p-0)/10):(p<25?(0.005039999999999999+(-0.0017999999999999995)*(p-10)/15):(p<50?(0.00324+(-0.0006479999999999997)*(p-25)/25):(p<100?(0.002592+(-0.00019200000000000033)*(p-50)/50):(p<250?(0.0024+(-0.0001333333333333334)*(p-100)/150):0.0022666666666666664))))))-(p<=0?0.0054:(p<10?(0.0054+(-0.0016200000000000003)*(p-0)/10):(p<25?(0.00378+(-0.0013499999999999996)*(p-10)/15):(p<50?(0.0024300000000000003+(-0.0004860000000000003)*(p-25)/25):(p<100?(0.001944+(-0.00014400000000000003)*(p-50)/50):(p<250?(0.0018+(-0.00010000000000000005)*(p-100)/150):0.0017)))))))*(g-(-3))/1.5):(g<0?((p<=0?0.0072:(p<10?(0.0072+(-0.0021600000000000005)*(p-0)/10):(p<25?(0.005039999999999999+(-0.0017999999999999995)*(p-10)/15):(p<50?(0.00324+(-0.0006479999999999997)*(p-25)/25):(p<100?(0.002592+(-0.00019200000000000033)*(p-50)/50):(p<250?(0.0024+(-0.0001333333333333334)*(p-100)/150):0.0022666666666666664))))))+((p<=0?0.0093:(p<10?(0.0093+(-0.002789999999999999)*(p-0)/10):(p<25?(0.00651+(-0.002325)*(p-10)/15):(p<50?(0.004185+(-0.0008370000000000001)*(p-25)/25):(p<100?(0.0033480000000000003+(-0.0002480000000000004)*(p-50)/50):(p<250?(0.0031+(-0.00017222222222222248)*(p-100)/150):0.0029277777777777774))))))-(p<=0?0.0072:(p<10?(0.0072+(-0.0021600000000000005)*(p-0)/10):(p<25?(0.005039999999999999+(-0.0017999999999999995)*(p-10)/15):(p<50?(0.00324+(-0.0006479999999999997)*(p-25)/25):(p<100?(0.002592+(-0.00019200000000000033)*(p-50)/50):(p<250?(0.0024+(-0.0001333333333333334)*(p-100)/150):0.0022666666666666664)))))))*(g-(-1.5))/1.5):(p<=0?0.0093:(p<10?(0.0093+(-0.002789999999999999)*(p-0)/10):(p<25?(0.00651+(-0.002325)*(p-10)/15):(p<50?(0.004185+(-0.0008370000000000001)*(p-25)/25):(p<100?(0.0033480000000000003+(-0.0002480000000000004)*(p-50)/50):(p<250?(0.0031+(-0.00017222222222222248)*(p-100)/150):0.0029277777777777774))))))))))))))))))))}
.func QIF(s) {max(s,1e-6)/100}
RCP CP 0 30000
RCS S 0 120000
BDRIVE CP 0 I={0.000002*(1+0.5*sin(6283.185307179586*time))*sin(2858849.3147667116*time)}
C11 S 0 5e-8
BIFP IP 0 I={1*(V(S)>0)*QIF(V(S))^1.5*IFP(max(V(IP),0)/QIF(V(S)),V(IG)/QIF(V(S)))}
BIFS S 0 I={1*(V(S)>0)*QIF(V(S))^1.5*IFS(max(V(IP),0)/QIF(V(S)),V(IG)/QIF(V(S)))}
BIFG IG 0 I={0.0001*max(V(IG),0)^1.5}
CIG IG 0 5e-12
CIP IP 0 6e-12
CIGP IG IP 7e-15
R13 N_BPLUS_FILT S 27000
R12P CP CW 30
R12S IG IS 30
L12P CW N_BPLUS_FILT 0.001
L12S IS AVC 0.001
K12 L12P L12S 0.02
C12P CP N_BPLUS_FILT 1.223538022489286e-10
C12S IG AVC 1.223538022489286e-10
R12LP CP N_BPLUS_FILT 1424959.199722886
R12LS IG AVC 1424959.199722886
R14P IP PW 30
R14S U SW 30
L14P PW N_BPLUS_FILT 0.001
L14S SW H 0.001
K14 L14P L14S 0.02
C14P IP N_BPLUS_FILT 1.223538022489286e-10
C14S U H 1.223538022489286e-10
R14LP IP N_BPLUS_FILT 1424959.199722886
R14LS U H 1424959.199722886
R7 AVC 0 4700000
C8 AVC 0 5e-8
BDUP U 0 I={0.0001*max(V(U),0)^1.5}
BDLOW AVC 0 I={0.0001*max(V(AVC),0)^1.5}
R17 U AVC 4700000
.options method=trap maxord=2 reltol=1e-6 abstol=1e-12
* DC operating point initializes hot equilibrium; no UIC. JS uses implicit midpoint at 2.2893772893772893e-8 s.
.tran 2.2893772893772893e-8 0.006 0 2.2893772893772893e-8
.print tran V(N_BPLUS_FILT) V(S) V(AVC) V(IG) V(IP) V(H) V(G) V(P) V(T) V(SPEAKER)
.end
