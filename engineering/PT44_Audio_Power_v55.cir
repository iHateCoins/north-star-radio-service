PT-44 v0.55 coupled audio/power - uncalibrated explicit parameters
* Factory topology: Philco p.38. Load resistors, field L and lamp hot R are test inputs.
* B-minus is the reference; no chassis bond. Rectifier is a single-point 3/2-power approximation.
VMAIN LINE 0 SIN(0 162.63455967290594 60)
VLINE_LINK LINE LINE_IN 0
R30_40 LINE_IN PLATE 40
RLAMP LINE_IN PLATE 42
R30_80 PLATE HEATER_IN 80
RHEATERS HEATER_IN 0 692.6666666666667
BRECT PLATE N_BPLUS_RECT I={1*0.0026189140043946205*max(V(PLATE,N_BPLUS_RECT),0)^1.5}
C29A N_BPLUS_RECT 0 0.00002 IC=0
C29B N_BPLUS_FILT 0 0.00002 IC=0
VFIELD N_BPLUS_RECT FIELD_IN 0
R28 FIELD_IN FIELD_L 500
LFIELD FIELD_L N_BPLUS_FILT 5 IC=0
.options reltol=1e-5 abstol=1e-9 vntol=1e-5 method=gear maxord=2
* A/B are supplied rails. Transformer secondary is reflected, not galvanically bonded to B-minus.
.func TRI(p,g) {(g<=-4?(p<=0?0:(p<50?(0+(0)*(p-0)/50):(p<100?(0+(0)*(p-50)/50):(p<150?(0+(0)*(p-100)/50):(p<200?(0+(0)*(p-150)/50):(p<250?(0+(0)*(p-200)/50):0)))))):(g<-3?((p<=0?0:(p<50?(0+(0)*(p-0)/50):(p<100?(0+(0)*(p-50)/50):(p<150?(0+(0)*(p-100)/50):(p<200?(0+(0)*(p-150)/50):(p<250?(0+(0)*(p-200)/50):0))))))+((p<=0?0:(p<50?(0+(0)*(p-0)/50):(p<100?(0+(0)*(p-50)/50):(p<150?(0+(0)*(p-100)/50):(p<200?(0+(0)*(p-150)/50):(p<250?(0+(0.00004)*(p-200)/50):0.00004))))))-(p<=0?0:(p<50?(0+(0)*(p-0)/50):(p<100?(0+(0)*(p-50)/50):(p<150?(0+(0)*(p-100)/50):(p<200?(0+(0)*(p-150)/50):(p<250?(0+(0)*(p-200)/50):0)))))))*(g-(-4))/1):(g<-2?((p<=0?0:(p<50?(0+(0)*(p-0)/50):(p<100?(0+(0)*(p-50)/50):(p<150?(0+(0)*(p-100)/50):(p<200?(0+(0)*(p-150)/50):(p<250?(0+(0.00004)*(p-200)/50):0.00004))))))+((p<=0?0:(p<50?(0+(0)*(p-0)/50):(p<100?(0+(0)*(p-50)/50):(p<150?(0+(0)*(p-100)/50):(p<200?(0+(0.00015)*(p-150)/50):(p<250?(0.00015+(0.00025)*(p-200)/50):0.0004))))))-(p<=0?0:(p<50?(0+(0)*(p-0)/50):(p<100?(0+(0)*(p-50)/50):(p<150?(0+(0)*(p-100)/50):(p<200?(0+(0)*(p-150)/50):(p<250?(0+(0.00004)*(p-200)/50):0.00004)))))))*(g-(-3))/1):(g<-1.5?((p<=0?0:(p<50?(0+(0)*(p-0)/50):(p<100?(0+(0)*(p-50)/50):(p<150?(0+(0)*(p-100)/50):(p<200?(0+(0.00015)*(p-150)/50):(p<250?(0.00015+(0.00025)*(p-200)/50):0.0004))))))+((p<=0?0:(p<50?(0+(0)*(p-0)/50):(p<100?(0+(0)*(p-50)/50):(p<150?(0+(0.0001)*(p-100)/50):(p<200?(0.0001+(0.00030000000000000003)*(p-150)/50):(p<250?(0.0004+(0.0003199999999999999)*(p-200)/50):0.0007199999999999999))))))-(p<=0?0:(p<50?(0+(0)*(p-0)/50):(p<100?(0+(0)*(p-50)/50):(p<150?(0+(0)*(p-100)/50):(p<200?(0+(0.00015)*(p-150)/50):(p<250?(0.00015+(0.00025)*(p-200)/50):0.0004)))))))*(g-(-2))/0.5):(g<-1?((p<=0?0:(p<50?(0+(0)*(p-0)/50):(p<100?(0+(0)*(p-50)/50):(p<150?(0+(0.0001)*(p-100)/50):(p<200?(0.0001+(0.00030000000000000003)*(p-150)/50):(p<250?(0.0004+(0.0003199999999999999)*(p-200)/50):0.0007199999999999999))))))+((p<=0?0:(p<50?(0+(0)*(p-0)/50):(p<100?(0+(0.00008)*(p-50)/50):(p<150?(0.00008+(0.00032)*(p-100)/50):(p<200?(0.0004+(0.00041999999999999996)*(p-150)/50):(p<250?(0.00082+(0.00047999999999999996)*(p-200)/50):0.0013))))))-(p<=0?0:(p<50?(0+(0)*(p-0)/50):(p<100?(0+(0)*(p-50)/50):(p<150?(0+(0.0001)*(p-100)/50):(p<200?(0.0001+(0.00030000000000000003)*(p-150)/50):(p<250?(0.0004+(0.0003199999999999999)*(p-200)/50):0.0007199999999999999)))))))*(g-(-1.5))/0.5):(g<-0.5?((p<=0?0:(p<50?(0+(0)*(p-0)/50):(p<100?(0+(0.00008)*(p-50)/50):(p<150?(0.00008+(0.00032)*(p-100)/50):(p<200?(0.0004+(0.00041999999999999996)*(p-150)/50):(p<250?(0.00082+(0.00047999999999999996)*(p-200)/50):0.0013))))))+((p<=0?0:(p<50?(0+(0.00008)*(p-0)/50):(p<100?(0.00008+(0.00039)*(p-50)/50):(p<150?(0.00047+(0.00048)*(p-100)/50):(p<200?(0.00095+(0.0004999999999999999)*(p-150)/50):(p<250?(0.00145+(0.0004000000000000002)*(p-200)/50):0.00185))))))-(p<=0?0:(p<50?(0+(0)*(p-0)/50):(p<100?(0+(0.00008)*(p-50)/50):(p<150?(0.00008+(0.00032)*(p-100)/50):(p<200?(0.0004+(0.00041999999999999996)*(p-150)/50):(p<250?(0.00082+(0.00047999999999999996)*(p-200)/50):0.0013)))))))*(g-(-1))/0.5):(g<0?((p<=0?0:(p<50?(0+(0.00008)*(p-0)/50):(p<100?(0.00008+(0.00039)*(p-50)/50):(p<150?(0.00047+(0.00048)*(p-100)/50):(p<200?(0.00095+(0.0004999999999999999)*(p-150)/50):(p<250?(0.00145+(0.0004000000000000002)*(p-200)/50):0.00185))))))+((p<=0?0:(p<50?(0+(0.00035)*(p-0)/50):(p<100?(0.00035+(0.00065)*(p-50)/50):(p<150?(0.001+(0.0005)*(p-100)/50):(p<200?(0.0015+(0.0005)*(p-150)/50):(p<250?(0.002+(0.0005)*(p-200)/50):0.0025))))))-(p<=0?0:(p<50?(0+(0.00008)*(p-0)/50):(p<100?(0.00008+(0.00039)*(p-50)/50):(p<150?(0.00047+(0.00048)*(p-100)/50):(p<200?(0.00095+(0.0004999999999999999)*(p-150)/50):(p<250?(0.00145+(0.0004000000000000002)*(p-200)/50):0.00185)))))))*(g-(-0.5))/0.5):(g<0.5?((p<=0?0:(p<50?(0+(0.00035)*(p-0)/50):(p<100?(0.00035+(0.00065)*(p-50)/50):(p<150?(0.001+(0.0005)*(p-100)/50):(p<200?(0.0015+(0.0005)*(p-150)/50):(p<250?(0.002+(0.0005)*(p-200)/50):0.0025))))))+((p<=0?0:(p<50?(0+(0.00065)*(p-0)/50):(p<100?(0.00065+(0.0007999999999999999)*(p-50)/50):(p<150?(0.00145+(0.0005500000000000001)*(p-100)/50):(p<200?(0.002+(0.0005499999999999997)*(p-150)/50):(p<250?(0.0025499999999999997+(0.0005500000000000001)*(p-200)/50):0.0031))))))-(p<=0?0:(p<50?(0+(0.00035)*(p-0)/50):(p<100?(0.00035+(0.00065)*(p-50)/50):(p<150?(0.001+(0.0005)*(p-100)/50):(p<200?(0.0015+(0.0005)*(p-150)/50):(p<250?(0.002+(0.0005)*(p-200)/50):0.0025)))))))*(g-(0))/0.5):(g<1?((p<=0?0:(p<50?(0+(0.00065)*(p-0)/50):(p<100?(0.00065+(0.0007999999999999999)*(p-50)/50):(p<150?(0.00145+(0.0005500000000000001)*(p-100)/50):(p<200?(0.002+(0.0005499999999999997)*(p-150)/50):(p<250?(0.0025499999999999997+(0.0005500000000000001)*(p-200)/50):0.0031))))))+((p<=0?0:(p<50?(0+(0.001)*(p-0)/50):(p<100?(0.001+(0.0009)*(p-50)/50):(p<150?(0.0019+(0.0006000000000000001)*(p-100)/50):(p<200?(0.0025+(0.0005999999999999998)*(p-150)/50):(p<250?(0.0031+(0.0005500000000000001)*(p-200)/50):0.00365))))))-(p<=0?0:(p<50?(0+(0.00065)*(p-0)/50):(p<100?(0.00065+(0.0007999999999999999)*(p-50)/50):(p<150?(0.00145+(0.0005500000000000001)*(p-100)/50):(p<200?(0.002+(0.0005499999999999997)*(p-150)/50):(p<250?(0.0025499999999999997+(0.0005500000000000001)*(p-200)/50):0.0031)))))))*(g-(0.5))/0.5):(p<=0?0:(p<50?(0+(0.001)*(p-0)/50):(p<100?(0.001+(0.0009)*(p-50)/50):(p<150?(0.0019+(0.0006000000000000001)*(p-100)/50):(p<200?(0.0025+(0.0005999999999999998)*(p-150)/50):(p<250?(0.0031+(0.0005500000000000001)*(p-200)/50):0.00365)))))))))))))))}
.func OUTP(p,g) {(g<=-20?(p<=0?0:(p<10?(0+(0)*(p-0)/10):(p<25?(0+(0)*(p-10)/15):(p<50?(0+(0)*(p-25)/25):(p<100?(0+(0)*(p-50)/50):(p<110?(0+(0)*(p-100)/10):(p<200?(0+(0)*(p-110)/90):(p<300?(0+(0)*(p-200)/100):(p<400?(0+(0)*(p-300)/100):0))))))))):(g<-16?((p<=0?0:(p<10?(0+(0)*(p-0)/10):(p<25?(0+(0)*(p-10)/15):(p<50?(0+(0)*(p-25)/25):(p<100?(0+(0)*(p-50)/50):(p<110?(0+(0)*(p-100)/10):(p<200?(0+(0)*(p-110)/90):(p<300?(0+(0)*(p-200)/100):(p<400?(0+(0)*(p-300)/100):0)))))))))+((p<=0?0:(p<10?(0+(0.00025)*(p-0)/10):(p<25?(0.00025+(0.00055)*(p-10)/15):(p<50?(0.0008+(0.00019999999999999998)*(p-25)/25):(p<100?(0.001+(0.001)*(p-50)/50):(p<110?(0.002+(0.0002000000000000001)*(p-100)/10):(p<200?(0.0022+(0.0018)*(p-110)/90):(p<300?(0.004+(0.002)*(p-200)/100):(p<400?(0.006+(0.002)*(p-300)/100):0.008)))))))))-(p<=0?0:(p<10?(0+(0)*(p-0)/10):(p<25?(0+(0)*(p-10)/15):(p<50?(0+(0)*(p-25)/25):(p<100?(0+(0)*(p-50)/50):(p<110?(0+(0)*(p-100)/10):(p<200?(0+(0)*(p-110)/90):(p<300?(0+(0)*(p-200)/100):(p<400?(0+(0)*(p-300)/100):0))))))))))*(g-(-20))/4):(g<-12?((p<=0?0:(p<10?(0+(0.00025)*(p-0)/10):(p<25?(0.00025+(0.00055)*(p-10)/15):(p<50?(0.0008+(0.00019999999999999998)*(p-25)/25):(p<100?(0.001+(0.001)*(p-50)/50):(p<110?(0.002+(0.0002000000000000001)*(p-100)/10):(p<200?(0.0022+(0.0018)*(p-110)/90):(p<300?(0.004+(0.002)*(p-200)/100):(p<400?(0.006+(0.002)*(p-300)/100):0.008)))))))))+((p<=0?0:(p<10?(0+(0.003)*(p-0)/10):(p<25?(0.003+(0.006600000000000001)*(p-10)/15):(p<50?(0.009600000000000001+(0.0023999999999999994)*(p-25)/25):(p<100?(0.012+(0.005000000000000001)*(p-50)/50):(p<110?(0.017+(0.0005000000000000004)*(p-100)/10):(p<200?(0.0175+(0.0024999999999999988)*(p-110)/90):(p<300?(0.02+(0.0019999999999999983)*(p-200)/100):(p<400?(0.022+(0.0020000000000000018)*(p-300)/100):0.024)))))))))-(p<=0?0:(p<10?(0+(0.00025)*(p-0)/10):(p<25?(0.00025+(0.00055)*(p-10)/15):(p<50?(0.0008+(0.00019999999999999998)*(p-25)/25):(p<100?(0.001+(0.001)*(p-50)/50):(p<110?(0.002+(0.0002000000000000001)*(p-100)/10):(p<200?(0.0022+(0.0018)*(p-110)/90):(p<300?(0.004+(0.002)*(p-200)/100):(p<400?(0.006+(0.002)*(p-300)/100):0.008))))))))))*(g-(-16))/4):(g<-10?((p<=0?0:(p<10?(0+(0.003)*(p-0)/10):(p<25?(0.003+(0.006600000000000001)*(p-10)/15):(p<50?(0.009600000000000001+(0.0023999999999999994)*(p-25)/25):(p<100?(0.012+(0.005000000000000001)*(p-50)/50):(p<110?(0.017+(0.0005000000000000004)*(p-100)/10):(p<200?(0.0175+(0.0024999999999999988)*(p-110)/90):(p<300?(0.02+(0.0019999999999999983)*(p-200)/100):(p<400?(0.022+(0.0020000000000000018)*(p-300)/100):0.024)))))))))+((p<=0?0:(p<10?(0+(0.006)*(p-0)/10):(p<25?(0.006+(0.013200000000000002)*(p-10)/15):(p<50?(0.019200000000000002+(0.004799999999999999)*(p-25)/25):(p<100?(0.024+(0.005999999999999998)*(p-50)/50):(p<110?(0.03+(0.0005000000000000004)*(p-100)/10):(p<200?(0.0305+(0.0025000000000000022)*(p-110)/90):(p<300?(0.033+(0.0020000000000000018)*(p-200)/100):(p<400?(0.035+(0.001999999999999995)*(p-300)/100):0.037)))))))))-(p<=0?0:(p<10?(0+(0.003)*(p-0)/10):(p<25?(0.003+(0.006600000000000001)*(p-10)/15):(p<50?(0.009600000000000001+(0.0023999999999999994)*(p-25)/25):(p<100?(0.012+(0.005000000000000001)*(p-50)/50):(p<110?(0.017+(0.0005000000000000004)*(p-100)/10):(p<200?(0.0175+(0.0024999999999999988)*(p-110)/90):(p<300?(0.02+(0.0019999999999999983)*(p-200)/100):(p<400?(0.022+(0.0020000000000000018)*(p-300)/100):0.024))))))))))*(g-(-12))/2):(g<-8?((p<=0?0:(p<10?(0+(0.006)*(p-0)/10):(p<25?(0.006+(0.013200000000000002)*(p-10)/15):(p<50?(0.019200000000000002+(0.004799999999999999)*(p-25)/25):(p<100?(0.024+(0.005999999999999998)*(p-50)/50):(p<110?(0.03+(0.0005000000000000004)*(p-100)/10):(p<200?(0.0305+(0.0025000000000000022)*(p-110)/90):(p<300?(0.033+(0.0020000000000000018)*(p-200)/100):(p<400?(0.035+(0.001999999999999995)*(p-300)/100):0.037)))))))))+((p<=0?0:(p<10?(0+(0.0095)*(p-0)/10):(p<25?(0.0095+(0.020900000000000002)*(p-10)/15):(p<50?(0.030400000000000003+(0.007599999999999996)*(p-25)/25):(p<100?(0.038+(0.006999999999999999)*(p-50)/50):(p<110?(0.045+(0.0005000000000000004)*(p-100)/10):(p<200?(0.0455+(0.004500000000000004)*(p-110)/90):(p<300?(0.05+(0.0029999999999999957)*(p-200)/100):(p<400?(0.053+(0.0020000000000000018)*(p-300)/100):0.055)))))))))-(p<=0?0:(p<10?(0+(0.006)*(p-0)/10):(p<25?(0.006+(0.013200000000000002)*(p-10)/15):(p<50?(0.019200000000000002+(0.004799999999999999)*(p-25)/25):(p<100?(0.024+(0.005999999999999998)*(p-50)/50):(p<110?(0.03+(0.0005000000000000004)*(p-100)/10):(p<200?(0.0305+(0.0025000000000000022)*(p-110)/90):(p<300?(0.033+(0.0020000000000000018)*(p-200)/100):(p<400?(0.035+(0.001999999999999995)*(p-300)/100):0.037))))))))))*(g-(-10))/2):(g<-7.5?((p<=0?0:(p<10?(0+(0.0095)*(p-0)/10):(p<25?(0.0095+(0.020900000000000002)*(p-10)/15):(p<50?(0.030400000000000003+(0.007599999999999996)*(p-25)/25):(p<100?(0.038+(0.006999999999999999)*(p-50)/50):(p<110?(0.045+(0.0005000000000000004)*(p-100)/10):(p<200?(0.0455+(0.004500000000000004)*(p-110)/90):(p<300?(0.05+(0.0029999999999999957)*(p-200)/100):(p<400?(0.053+(0.0020000000000000018)*(p-300)/100):0.055)))))))))+((p<=0?0:(p<10?(0+(0.01025)*(p-0)/10):(p<25?(0.01025+(0.02255)*(p-10)/15):(p<50?(0.0328+(0.008199999999999999)*(p-25)/25):(p<100?(0.041+(0.007229999999999993)*(p-50)/50):(p<110?(0.048229999999999995+(0.0007700000000000068)*(p-100)/10):(p<200?(0.049+(0.003999999999999997)*(p-110)/90):(p<300?(0.053+(0.0030000000000000027)*(p-200)/100):(p<400?(0.056+(0.0020000000000000018)*(p-300)/100):0.058)))))))))-(p<=0?0:(p<10?(0+(0.0095)*(p-0)/10):(p<25?(0.0095+(0.020900000000000002)*(p-10)/15):(p<50?(0.030400000000000003+(0.007599999999999996)*(p-25)/25):(p<100?(0.038+(0.006999999999999999)*(p-50)/50):(p<110?(0.045+(0.0005000000000000004)*(p-100)/10):(p<200?(0.0455+(0.004500000000000004)*(p-110)/90):(p<300?(0.05+(0.0029999999999999957)*(p-200)/100):(p<400?(0.053+(0.0020000000000000018)*(p-300)/100):0.055))))))))))*(g-(-8))/0.5):(g<-6?((p<=0?0:(p<10?(0+(0.01025)*(p-0)/10):(p<25?(0.01025+(0.02255)*(p-10)/15):(p<50?(0.0328+(0.008199999999999999)*(p-25)/25):(p<100?(0.041+(0.007229999999999993)*(p-50)/50):(p<110?(0.048229999999999995+(0.0007700000000000068)*(p-100)/10):(p<200?(0.049+(0.003999999999999997)*(p-110)/90):(p<300?(0.053+(0.0030000000000000027)*(p-200)/100):(p<400?(0.056+(0.0020000000000000018)*(p-300)/100):0.058)))))))))+((p<=0?0:(p<10?(0+(0.01425)*(p-0)/10):(p<25?(0.01425+(0.03135)*(p-10)/15):(p<50?(0.0456+(0.0114)*(p-25)/25):(p<100?(0.057+(0.008)*(p-50)/50):(p<110?(0.065+(0.0005000000000000004)*(p-100)/10):(p<200?(0.0655+(0.004500000000000004)*(p-110)/90):(p<300?(0.07+(0.002999999999999989)*(p-200)/100):(p<400?(0.073+(0.0030000000000000027)*(p-300)/100):0.076)))))))))-(p<=0?0:(p<10?(0+(0.01025)*(p-0)/10):(p<25?(0.01025+(0.02255)*(p-10)/15):(p<50?(0.0328+(0.008199999999999999)*(p-25)/25):(p<100?(0.041+(0.007229999999999993)*(p-50)/50):(p<110?(0.048229999999999995+(0.0007700000000000068)*(p-100)/10):(p<200?(0.049+(0.003999999999999997)*(p-110)/90):(p<300?(0.053+(0.0030000000000000027)*(p-200)/100):(p<400?(0.056+(0.0020000000000000018)*(p-300)/100):0.058))))))))))*(g-(-7.5))/1.5):(g<-4?((p<=0?0:(p<10?(0+(0.01425)*(p-0)/10):(p<25?(0.01425+(0.03135)*(p-10)/15):(p<50?(0.0456+(0.0114)*(p-25)/25):(p<100?(0.057+(0.008)*(p-50)/50):(p<110?(0.065+(0.0005000000000000004)*(p-100)/10):(p<200?(0.0655+(0.004500000000000004)*(p-110)/90):(p<300?(0.07+(0.002999999999999989)*(p-200)/100):(p<400?(0.073+(0.0030000000000000027)*(p-300)/100):0.076)))))))))+((p<=0?0:(p<10?(0+(0.01925)*(p-0)/10):(p<25?(0.01925+(0.04235)*(p-10)/15):(p<50?(0.0616+(0.015399999999999997)*(p-25)/25):(p<100?(0.077+(0.007000000000000006)*(p-50)/50):(p<110?(0.084+(0.0005000000000000004)*(p-100)/10):(p<200?(0.0845+(0.006499999999999992)*(p-110)/90):(p<300?(0.091+(0.0040000000000000036)*(p-200)/100):(p<400?(0.095+(0.0030000000000000027)*(p-300)/100):0.098)))))))))-(p<=0?0:(p<10?(0+(0.01425)*(p-0)/10):(p<25?(0.01425+(0.03135)*(p-10)/15):(p<50?(0.0456+(0.0114)*(p-25)/25):(p<100?(0.057+(0.008)*(p-50)/50):(p<110?(0.065+(0.0005000000000000004)*(p-100)/10):(p<200?(0.0655+(0.004500000000000004)*(p-110)/90):(p<300?(0.07+(0.002999999999999989)*(p-200)/100):(p<400?(0.073+(0.0030000000000000027)*(p-300)/100):0.076))))))))))*(g-(-6))/2):(g<-2?((p<=0?0:(p<10?(0+(0.01925)*(p-0)/10):(p<25?(0.01925+(0.04235)*(p-10)/15):(p<50?(0.0616+(0.015399999999999997)*(p-25)/25):(p<100?(0.077+(0.007000000000000006)*(p-50)/50):(p<110?(0.084+(0.0005000000000000004)*(p-100)/10):(p<200?(0.0845+(0.006499999999999992)*(p-110)/90):(p<300?(0.091+(0.0040000000000000036)*(p-200)/100):(p<400?(0.095+(0.0030000000000000027)*(p-300)/100):0.098)))))))))+((p<=0?0:(p<10?(0+(0.02525)*(p-0)/10):(p<25?(0.02525+(0.05555000000000001)*(p-10)/15):(p<50?(0.08080000000000001+(0.020199999999999996)*(p-25)/25):(p<100?(0.101+(0.007999999999999993)*(p-50)/50):(p<110?(0.109+(0.0005000000000000004)*(p-100)/10):(p<200?(0.1095+(0.009499999999999995)*(p-110)/90):(p<300?(0.119+(0.0050000000000000044)*(p-200)/100):(p<400?(0.124+(0.0030000000000000027)*(p-300)/100):0.127)))))))))-(p<=0?0:(p<10?(0+(0.01925)*(p-0)/10):(p<25?(0.01925+(0.04235)*(p-10)/15):(p<50?(0.0616+(0.015399999999999997)*(p-25)/25):(p<100?(0.077+(0.007000000000000006)*(p-50)/50):(p<110?(0.084+(0.0005000000000000004)*(p-100)/10):(p<200?(0.0845+(0.006499999999999992)*(p-110)/90):(p<300?(0.091+(0.0040000000000000036)*(p-200)/100):(p<400?(0.095+(0.0030000000000000027)*(p-300)/100):0.098))))))))))*(g-(-4))/2):(g<0?((p<=0?0:(p<10?(0+(0.02525)*(p-0)/10):(p<25?(0.02525+(0.05555000000000001)*(p-10)/15):(p<50?(0.08080000000000001+(0.020199999999999996)*(p-25)/25):(p<100?(0.101+(0.007999999999999993)*(p-50)/50):(p<110?(0.109+(0.0005000000000000004)*(p-100)/10):(p<200?(0.1095+(0.009499999999999995)*(p-110)/90):(p<300?(0.119+(0.0050000000000000044)*(p-200)/100):(p<400?(0.124+(0.0030000000000000027)*(p-300)/100):0.127)))))))))+((p<=0?0:(p<10?(0+(0.032)*(p-0)/10):(p<25?(0.032+(0.0704)*(p-10)/15):(p<50?(0.1024+(0.025599999999999998)*(p-25)/25):(p<100?(0.128+(0.008000000000000007)*(p-50)/50):(p<110?(0.136+(0.0005000000000000004)*(p-100)/10):(p<200?(0.1365+(0.00949999999999998)*(p-110)/90):(p<300?(0.146+(0.006000000000000005)*(p-200)/100):(p<400?(0.152+(0.0040000000000000036)*(p-300)/100):0.156)))))))))-(p<=0?0:(p<10?(0+(0.02525)*(p-0)/10):(p<25?(0.02525+(0.05555000000000001)*(p-10)/15):(p<50?(0.08080000000000001+(0.020199999999999996)*(p-25)/25):(p<100?(0.101+(0.007999999999999993)*(p-50)/50):(p<110?(0.109+(0.0005000000000000004)*(p-100)/10):(p<200?(0.1095+(0.009499999999999995)*(p-110)/90):(p<300?(0.119+(0.0050000000000000044)*(p-200)/100):(p<400?(0.124+(0.0030000000000000027)*(p-300)/100):0.127))))))))))*(g-(-2))/2):(g<2?((p<=0?0:(p<10?(0+(0.032)*(p-0)/10):(p<25?(0.032+(0.0704)*(p-10)/15):(p<50?(0.1024+(0.025599999999999998)*(p-25)/25):(p<100?(0.128+(0.008000000000000007)*(p-50)/50):(p<110?(0.136+(0.0005000000000000004)*(p-100)/10):(p<200?(0.1365+(0.00949999999999998)*(p-110)/90):(p<300?(0.146+(0.006000000000000005)*(p-200)/100):(p<400?(0.152+(0.0040000000000000036)*(p-300)/100):0.156)))))))))+((p<=0?0:(p<10?(0+(0.0385)*(p-0)/10):(p<25?(0.0385+(0.0847)*(p-10)/15):(p<50?(0.1232+(0.030799999999999994)*(p-25)/25):(p<100?(0.154+(0.01100000000000001)*(p-50)/50):(p<110?(0.165+(0.0005000000000000004)*(p-100)/10):(p<200?(0.1655+(0.010499999999999982)*(p-110)/90):(p<300?(0.176+(0.006000000000000005)*(p-200)/100):(p<400?(0.182+(0.0050000000000000044)*(p-300)/100):0.187)))))))))-(p<=0?0:(p<10?(0+(0.032)*(p-0)/10):(p<25?(0.032+(0.0704)*(p-10)/15):(p<50?(0.1024+(0.025599999999999998)*(p-25)/25):(p<100?(0.128+(0.008000000000000007)*(p-50)/50):(p<110?(0.136+(0.0005000000000000004)*(p-100)/10):(p<200?(0.1365+(0.00949999999999998)*(p-110)/90):(p<300?(0.146+(0.006000000000000005)*(p-200)/100):(p<400?(0.152+(0.0040000000000000036)*(p-300)/100):0.156))))))))))*(g-(0))/2):(g<4?((p<=0?0:(p<10?(0+(0.0385)*(p-0)/10):(p<25?(0.0385+(0.0847)*(p-10)/15):(p<50?(0.1232+(0.030799999999999994)*(p-25)/25):(p<100?(0.154+(0.01100000000000001)*(p-50)/50):(p<110?(0.165+(0.0005000000000000004)*(p-100)/10):(p<200?(0.1655+(0.010499999999999982)*(p-110)/90):(p<300?(0.176+(0.006000000000000005)*(p-200)/100):(p<400?(0.182+(0.0050000000000000044)*(p-300)/100):0.187)))))))))+((p<=0?0:(p<10?(0+(0.0455)*(p-0)/10):(p<25?(0.0455+(0.10010000000000001)*(p-10)/15):(p<50?(0.1456+(0.03639999999999999)*(p-25)/25):(p<100?(0.182+(0.01100000000000001)*(p-50)/50):(p<110?(0.193+(0.0005000000000000004)*(p-100)/10):(p<200?(0.1935+(0.011499999999999982)*(p-110)/90):(p<300?(0.205+(0.007000000000000006)*(p-200)/100):(p<400?(0.212+(0.0050000000000000044)*(p-300)/100):0.217)))))))))-(p<=0?0:(p<10?(0+(0.0385)*(p-0)/10):(p<25?(0.0385+(0.0847)*(p-10)/15):(p<50?(0.1232+(0.030799999999999994)*(p-25)/25):(p<100?(0.154+(0.01100000000000001)*(p-50)/50):(p<110?(0.165+(0.0005000000000000004)*(p-100)/10):(p<200?(0.1655+(0.010499999999999982)*(p-110)/90):(p<300?(0.176+(0.006000000000000005)*(p-200)/100):(p<400?(0.182+(0.0050000000000000044)*(p-300)/100):0.187))))))))))*(g-(2))/2):(g<6?((p<=0?0:(p<10?(0+(0.0455)*(p-0)/10):(p<25?(0.0455+(0.10010000000000001)*(p-10)/15):(p<50?(0.1456+(0.03639999999999999)*(p-25)/25):(p<100?(0.182+(0.01100000000000001)*(p-50)/50):(p<110?(0.193+(0.0005000000000000004)*(p-100)/10):(p<200?(0.1935+(0.011499999999999982)*(p-110)/90):(p<300?(0.205+(0.007000000000000006)*(p-200)/100):(p<400?(0.212+(0.0050000000000000044)*(p-300)/100):0.217)))))))))+((p<=0?0:(p<10?(0+(0.05275)*(p-0)/10):(p<25?(0.05275+(0.11605000000000001)*(p-10)/15):(p<50?(0.1688+(0.04219999999999999)*(p-25)/25):(p<100?(0.211+(0.01200000000000001)*(p-50)/50):(p<110?(0.223+(0.0005000000000000004)*(p-100)/10):(p<200?(0.2235+(0.01050000000000001)*(p-110)/90):(p<300?(0.234+(0.0069999999999999785)*(p-200)/100):(p<400?(0.241+(0.0050000000000000044)*(p-300)/100):0.246)))))))))-(p<=0?0:(p<10?(0+(0.0455)*(p-0)/10):(p<25?(0.0455+(0.10010000000000001)*(p-10)/15):(p<50?(0.1456+(0.03639999999999999)*(p-25)/25):(p<100?(0.182+(0.01100000000000001)*(p-50)/50):(p<110?(0.193+(0.0005000000000000004)*(p-100)/10):(p<200?(0.1935+(0.011499999999999982)*(p-110)/90):(p<300?(0.205+(0.007000000000000006)*(p-200)/100):(p<400?(0.212+(0.0050000000000000044)*(p-300)/100):0.217))))))))))*(g-(4))/2):(p<=0?0:(p<10?(0+(0.05275)*(p-0)/10):(p<25?(0.05275+(0.11605000000000001)*(p-10)/15):(p<50?(0.1688+(0.04219999999999999)*(p-25)/25):(p<100?(0.211+(0.01200000000000001)*(p-50)/50):(p<110?(0.223+(0.0005000000000000004)*(p-100)/10):(p<200?(0.2235+(0.01050000000000001)*(p-110)/90):(p<300?(0.234+(0.0069999999999999785)*(p-200)/100):(p<400?(0.241+(0.0050000000000000044)*(p-300)/100):0.246))))))))))))))))))))))}
.func OUTS(p,g) {(g<=-20?(p<=0?0:(p<10?(0+(0)*(p-0)/10):(p<25?(0+(0)*(p-10)/15):(p<50?(0+(0)*(p-25)/25):(p<100?(0+(0)*(p-50)/50):(p<110?(0+(0)*(p-100)/10):(p<200?(0+(0)*(p-110)/90):(p<300?(0+(0)*(p-200)/100):(p<400?(0+(0)*(p-300)/100):0))))))))):(g<-16?((p<=0?0:(p<10?(0+(0)*(p-0)/10):(p<25?(0+(0)*(p-10)/15):(p<50?(0+(0)*(p-25)/25):(p<100?(0+(0)*(p-50)/50):(p<110?(0+(0)*(p-100)/10):(p<200?(0+(0)*(p-110)/90):(p<300?(0+(0)*(p-200)/100):(p<400?(0+(0)*(p-300)/100):0)))))))))+((p<=0?0.0021551020408163268:(p<10?(0.0021551020408163268+(-0.0005387755102040821)*(p-0)/10):(p<25?(0.0016163265306122446+(-0.0007183673469387754)*(p-10)/15):(p<50?(0.0008979591836734693+(-0.0005387755102040815)*(p-25)/25):(p<100?(0.00035918367346938774+(-0.00016881632653061225)*(p-50)/50):(p<110?(0.0001903673469387755+(-0.000010775510204081624)*(p-100)/10):(p<200?(0.00017959183673469387+(-0.00008081632653061223)*(p-110)/90):(p<300?(0.00009877551020408164+(-0.00003053061224489796)*(p-200)/100):(p<400?(0.00006824489795918367+(-0.000014367346938775519)*(p-300)/100):0.000053877551020408154)))))))))-(p<=0?0:(p<10?(0+(0)*(p-0)/10):(p<25?(0+(0)*(p-10)/15):(p<50?(0+(0)*(p-25)/25):(p<100?(0+(0)*(p-50)/50):(p<110?(0+(0)*(p-100)/10):(p<200?(0+(0)*(p-110)/90):(p<300?(0+(0)*(p-200)/100):(p<400?(0+(0)*(p-300)/100):0))))))))))*(g-(-20))/4):(g<-12?((p<=0?0.0021551020408163268:(p<10?(0.0021551020408163268+(-0.0005387755102040821)*(p-0)/10):(p<25?(0.0016163265306122446+(-0.0007183673469387754)*(p-10)/15):(p<50?(0.0008979591836734693+(-0.0005387755102040815)*(p-25)/25):(p<100?(0.00035918367346938774+(-0.00016881632653061225)*(p-50)/50):(p<110?(0.0001903673469387755+(-0.000010775510204081624)*(p-100)/10):(p<200?(0.00017959183673469387+(-0.00008081632653061223)*(p-110)/90):(p<300?(0.00009877551020408164+(-0.00003053061224489796)*(p-200)/100):(p<400?(0.00006824489795918367+(-0.000014367346938775519)*(p-300)/100):0.000053877551020408154)))))))))+((p<=0?0.01714285714285714:(p<10?(0.01714285714285714+(-0.004285714285714285)*(p-0)/10):(p<25?(0.012857142857142855+(-0.0057142857142857125)*(p-10)/15):(p<50?(0.007142857142857143+(-0.004285714285714286)*(p-25)/25):(p<100?(0.0028571428571428567+(-0.0013428571428571424)*(p-50)/50):(p<110?(0.0015142857142857143+(-0.00008571428571428597)*(p-100)/10):(p<200?(0.0014285714285714284+(-0.0006428571428571426)*(p-110)/90):(p<300?(0.0007857142857142857+(-0.00024285714285714297)*(p-200)/100):(p<400?(0.0005428571428571428+(-0.00011428571428571428)*(p-300)/100):0.0004285714285714285)))))))))-(p<=0?0.0021551020408163268:(p<10?(0.0021551020408163268+(-0.0005387755102040821)*(p-0)/10):(p<25?(0.0016163265306122446+(-0.0007183673469387754)*(p-10)/15):(p<50?(0.0008979591836734693+(-0.0005387755102040815)*(p-25)/25):(p<100?(0.00035918367346938774+(-0.00016881632653061225)*(p-50)/50):(p<110?(0.0001903673469387755+(-0.000010775510204081624)*(p-100)/10):(p<200?(0.00017959183673469387+(-0.00008081632653061223)*(p-110)/90):(p<300?(0.00009877551020408164+(-0.00003053061224489796)*(p-200)/100):(p<400?(0.00006824489795918367+(-0.000014367346938775519)*(p-300)/100):0.000053877551020408154))))))))))*(g-(-16))/4):(g<-10?((p<=0?0.01714285714285714:(p<10?(0.01714285714285714+(-0.004285714285714285)*(p-0)/10):(p<25?(0.012857142857142855+(-0.0057142857142857125)*(p-10)/15):(p<50?(0.007142857142857143+(-0.004285714285714286)*(p-25)/25):(p<100?(0.0028571428571428567+(-0.0013428571428571424)*(p-50)/50):(p<110?(0.0015142857142857143+(-0.00008571428571428597)*(p-100)/10):(p<200?(0.0014285714285714284+(-0.0006428571428571426)*(p-110)/90):(p<300?(0.0007857142857142857+(-0.00024285714285714297)*(p-200)/100):(p<400?(0.0005428571428571428+(-0.00011428571428571428)*(p-300)/100):0.0004285714285714285)))))))))+((p<=0?0.02987755102040816:(p<10?(0.02987755102040816+(-0.007469387755102041)*(p-0)/10):(p<25?(0.02240816326530612+(-0.009959183673469388)*(p-10)/15):(p<50?(0.012448979591836731+(-0.007469387755102038)*(p-25)/25):(p<100?(0.004979591836734693+(-0.0023404081632653058)*(p-50)/50):(p<110?(0.0026391836734693873+(-0.00014938775510204075)*(p-100)/10):(p<200?(0.0024897959183673465+(-0.0011204081632653056)*(p-110)/90):(p<300?(0.001369387755102041+(-0.00042326530612244915)*(p-200)/100):(p<400?(0.0009461224489795918+(-0.0001991836734693878)*(p-300)/100):0.000746938775510204)))))))))-(p<=0?0.01714285714285714:(p<10?(0.01714285714285714+(-0.004285714285714285)*(p-0)/10):(p<25?(0.012857142857142855+(-0.0057142857142857125)*(p-10)/15):(p<50?(0.007142857142857143+(-0.004285714285714286)*(p-25)/25):(p<100?(0.0028571428571428567+(-0.0013428571428571424)*(p-50)/50):(p<110?(0.0015142857142857143+(-0.00008571428571428597)*(p-100)/10):(p<200?(0.0014285714285714284+(-0.0006428571428571426)*(p-110)/90):(p<300?(0.0007857142857142857+(-0.00024285714285714297)*(p-200)/100):(p<400?(0.0005428571428571428+(-0.00011428571428571428)*(p-300)/100):0.0004285714285714285))))))))))*(g-(-12))/2):(g<-8?((p<=0?0.02987755102040816:(p<10?(0.02987755102040816+(-0.007469387755102041)*(p-0)/10):(p<25?(0.02240816326530612+(-0.009959183673469388)*(p-10)/15):(p<50?(0.012448979591836731+(-0.007469387755102038)*(p-25)/25):(p<100?(0.004979591836734693+(-0.0023404081632653058)*(p-50)/50):(p<110?(0.0026391836734693873+(-0.00014938775510204075)*(p-100)/10):(p<200?(0.0024897959183673465+(-0.0011204081632653056)*(p-110)/90):(p<300?(0.001369387755102041+(-0.00042326530612244915)*(p-200)/100):(p<400?(0.0009461224489795918+(-0.0001991836734693878)*(p-300)/100):0.000746938775510204)))))))))+((p<=0?0.04457142857142857:(p<10?(0.04457142857142857+(-0.011142857142857142)*(p-0)/10):(p<25?(0.033428571428571426+(-0.014857142857142857)*(p-10)/15):(p<50?(0.01857142857142857+(-0.011142857142857142)*(p-25)/25):(p<100?(0.007428571428571428+(-0.0034914285714285707)*(p-50)/50):(p<110?(0.003937142857142857+(-0.00022285714285714313)*(p-100)/10):(p<200?(0.003714285714285714+(-0.001671428571428571)*(p-110)/90):(p<300?(0.0020428571428571427+(-0.0006314285714285714)*(p-200)/100):(p<400?(0.0014114285714285713+(-0.00029714285714285715)*(p-300)/100):0.0011142857142857141)))))))))-(p<=0?0.02987755102040816:(p<10?(0.02987755102040816+(-0.007469387755102041)*(p-0)/10):(p<25?(0.02240816326530612+(-0.009959183673469388)*(p-10)/15):(p<50?(0.012448979591836731+(-0.007469387755102038)*(p-25)/25):(p<100?(0.004979591836734693+(-0.0023404081632653058)*(p-50)/50):(p<110?(0.0026391836734693873+(-0.00014938775510204075)*(p-100)/10):(p<200?(0.0024897959183673465+(-0.0011204081632653056)*(p-110)/90):(p<300?(0.001369387755102041+(-0.00042326530612244915)*(p-200)/100):(p<400?(0.0009461224489795918+(-0.0001991836734693878)*(p-300)/100):0.000746938775510204))))))))))*(g-(-10))/2):(g<-7.5?((p<=0?0.04457142857142857:(p<10?(0.04457142857142857+(-0.011142857142857142)*(p-0)/10):(p<25?(0.033428571428571426+(-0.014857142857142857)*(p-10)/15):(p<50?(0.01857142857142857+(-0.011142857142857142)*(p-25)/25):(p<100?(0.007428571428571428+(-0.0034914285714285707)*(p-50)/50):(p<110?(0.003937142857142857+(-0.00022285714285714313)*(p-100)/10):(p<200?(0.003714285714285714+(-0.001671428571428571)*(p-110)/90):(p<300?(0.0020428571428571427+(-0.0006314285714285714)*(p-200)/100):(p<400?(0.0014114285714285713+(-0.00029714285714285715)*(p-300)/100):0.0011142857142857141)))))))))+((p<=0?0.047999999999999994:(p<10?(0.047999999999999994+(-0.012000000000000004)*(p-0)/10):(p<25?(0.03599999999999999+(-0.015999999999999993)*(p-10)/15):(p<50?(0.019999999999999997+(-0.011999999999999999)*(p-25)/25):(p<100?(0.007999999999999998+(-0.0037599999999999995)*(p-50)/50):(p<110?(0.004239999999999999+(-0.00023999999999999976)*(p-100)/10):(p<200?(0.003999999999999999+(-0.0017999999999999995)*(p-110)/90):(p<300?(0.0021999999999999997+(-0.0006799999999999998)*(p-200)/100):(p<400?(0.0015199999999999999+(-0.0003200000000000002)*(p-300)/100):0.0011999999999999997)))))))))-(p<=0?0.04457142857142857:(p<10?(0.04457142857142857+(-0.011142857142857142)*(p-0)/10):(p<25?(0.033428571428571426+(-0.014857142857142857)*(p-10)/15):(p<50?(0.01857142857142857+(-0.011142857142857142)*(p-25)/25):(p<100?(0.007428571428571428+(-0.0034914285714285707)*(p-50)/50):(p<110?(0.003937142857142857+(-0.00022285714285714313)*(p-100)/10):(p<200?(0.003714285714285714+(-0.001671428571428571)*(p-110)/90):(p<300?(0.0020428571428571427+(-0.0006314285714285714)*(p-200)/100):(p<400?(0.0014114285714285713+(-0.00029714285714285715)*(p-300)/100):0.0011142857142857141))))))))))*(g-(-8))/0.5):(g<-6?((p<=0?0.047999999999999994:(p<10?(0.047999999999999994+(-0.012000000000000004)*(p-0)/10):(p<25?(0.03599999999999999+(-0.015999999999999993)*(p-10)/15):(p<50?(0.019999999999999997+(-0.011999999999999999)*(p-25)/25):(p<100?(0.007999999999999998+(-0.0037599999999999995)*(p-50)/50):(p<110?(0.004239999999999999+(-0.00023999999999999976)*(p-100)/10):(p<200?(0.003999999999999999+(-0.0017999999999999995)*(p-110)/90):(p<300?(0.0021999999999999997+(-0.0006799999999999998)*(p-200)/100):(p<400?(0.0015199999999999999+(-0.0003200000000000002)*(p-300)/100):0.0011999999999999997)))))))))+((p<=0?0.06416326530612244:(p<10?(0.06416326530612244+(-0.016040816326530614)*(p-0)/10):(p<25?(0.04812244897959183+(-0.02138775510204081)*(p-10)/15):(p<50?(0.02673469387755102+(-0.01604081632653061)*(p-25)/25):(p<100?(0.010693877551020407+(-0.005026122448979592)*(p-50)/50):(p<110?(0.005667755102040815+(-0.0003208163265306114)*(p-100)/10):(p<200?(0.005346938775510204+(-0.0024061224489795915)*(p-110)/90):(p<300?(0.002940816326530612+(-0.0009089795918367349)*(p-200)/100):(p<400?(0.0020318367346938773+(-0.0004277551020408165)*(p-300)/100):0.0016040816326530608)))))))))-(p<=0?0.047999999999999994:(p<10?(0.047999999999999994+(-0.012000000000000004)*(p-0)/10):(p<25?(0.03599999999999999+(-0.015999999999999993)*(p-10)/15):(p<50?(0.019999999999999997+(-0.011999999999999999)*(p-25)/25):(p<100?(0.007999999999999998+(-0.0037599999999999995)*(p-50)/50):(p<110?(0.004239999999999999+(-0.00023999999999999976)*(p-100)/10):(p<200?(0.003999999999999999+(-0.0017999999999999995)*(p-110)/90):(p<300?(0.0021999999999999997+(-0.0006799999999999998)*(p-200)/100):(p<400?(0.0015199999999999999+(-0.0003200000000000002)*(p-300)/100):0.0011999999999999997))))))))))*(g-(-7.5))/1.5):(g<-4?((p<=0?0.06416326530612244:(p<10?(0.06416326530612244+(-0.016040816326530614)*(p-0)/10):(p<25?(0.04812244897959183+(-0.02138775510204081)*(p-10)/15):(p<50?(0.02673469387755102+(-0.01604081632653061)*(p-25)/25):(p<100?(0.010693877551020407+(-0.005026122448979592)*(p-50)/50):(p<110?(0.005667755102040815+(-0.0003208163265306114)*(p-100)/10):(p<200?(0.005346938775510204+(-0.0024061224489795915)*(p-110)/90):(p<300?(0.002940816326530612+(-0.0009089795918367349)*(p-200)/100):(p<400?(0.0020318367346938773+(-0.0004277551020408165)*(p-300)/100):0.0016040816326530608)))))))))+((p<=0?0.08277551020408162:(p<10?(0.08277551020408162+(-0.020693877551020402)*(p-0)/10):(p<25?(0.06208163265306122+(-0.027591836734693877)*(p-10)/15):(p<50?(0.034489795918367344+(-0.02069387755102041)*(p-25)/25):(p<100?(0.013795918367346937+(-0.00648408163265306)*(p-50)/50):(p<110?(0.007311836734693876+(-0.0004138775510204081)*(p-100)/10):(p<200?(0.006897959183673468+(-0.00310408163265306)*(p-110)/90):(p<300?(0.0037938775510204083+(-0.00117265306122449)*(p-200)/100):(p<400?(0.0026212244897959184+(-0.0005518367346938782)*(p-300)/100):0.00206938775510204)))))))))-(p<=0?0.06416326530612244:(p<10?(0.06416326530612244+(-0.016040816326530614)*(p-0)/10):(p<25?(0.04812244897959183+(-0.02138775510204081)*(p-10)/15):(p<50?(0.02673469387755102+(-0.01604081632653061)*(p-25)/25):(p<100?(0.010693877551020407+(-0.005026122448979592)*(p-50)/50):(p<110?(0.005667755102040815+(-0.0003208163265306114)*(p-100)/10):(p<200?(0.005346938775510204+(-0.0024061224489795915)*(p-110)/90):(p<300?(0.002940816326530612+(-0.0009089795918367349)*(p-200)/100):(p<400?(0.0020318367346938773+(-0.0004277551020408165)*(p-300)/100):0.0016040816326530608))))))))))*(g-(-6))/2):(g<-2?((p<=0?0.08277551020408162:(p<10?(0.08277551020408162+(-0.020693877551020402)*(p-0)/10):(p<25?(0.06208163265306122+(-0.027591836734693877)*(p-10)/15):(p<50?(0.034489795918367344+(-0.02069387755102041)*(p-25)/25):(p<100?(0.013795918367346937+(-0.00648408163265306)*(p-50)/50):(p<110?(0.007311836734693876+(-0.0004138775510204081)*(p-100)/10):(p<200?(0.006897959183673468+(-0.00310408163265306)*(p-110)/90):(p<300?(0.0037938775510204083+(-0.00117265306122449)*(p-200)/100):(p<400?(0.0026212244897959184+(-0.0005518367346938782)*(p-300)/100):0.00206938775510204)))))))))+((p<=0?0.10726530612244897:(p<10?(0.10726530612244897+(-0.026816326530612236)*(p-0)/10):(p<25?(0.08044897959183674+(-0.035755102040816326)*(p-10)/15):(p<50?(0.04469387755102041+(-0.026816326530612247)*(p-25)/25):(p<100?(0.017877551020408163+(-0.008402448979591838)*(p-50)/50):(p<110?(0.009475102040816325+(-0.0005363265306122435)*(p-100)/10):(p<200?(0.008938775510204082+(-0.004022448979591836)*(p-110)/90):(p<300?(0.0049163265306122455+(-0.0015195918367346948)*(p-200)/100):(p<400?(0.0033967346938775507+(-0.0007151020408163265)*(p-300)/100):0.0026816326530612242)))))))))-(p<=0?0.08277551020408162:(p<10?(0.08277551020408162+(-0.020693877551020402)*(p-0)/10):(p<25?(0.06208163265306122+(-0.027591836734693877)*(p-10)/15):(p<50?(0.034489795918367344+(-0.02069387755102041)*(p-25)/25):(p<100?(0.013795918367346937+(-0.00648408163265306)*(p-50)/50):(p<110?(0.007311836734693876+(-0.0004138775510204081)*(p-100)/10):(p<200?(0.006897959183673468+(-0.00310408163265306)*(p-110)/90):(p<300?(0.0037938775510204083+(-0.00117265306122449)*(p-200)/100):(p<400?(0.0026212244897959184+(-0.0005518367346938782)*(p-300)/100):0.00206938775510204))))))))))*(g-(-4))/2):(g<0?((p<=0?0.10726530612244897:(p<10?(0.10726530612244897+(-0.026816326530612236)*(p-0)/10):(p<25?(0.08044897959183674+(-0.035755102040816326)*(p-10)/15):(p<50?(0.04469387755102041+(-0.026816326530612247)*(p-25)/25):(p<100?(0.017877551020408163+(-0.008402448979591838)*(p-50)/50):(p<110?(0.009475102040816325+(-0.0005363265306122435)*(p-100)/10):(p<200?(0.008938775510204082+(-0.004022448979591836)*(p-110)/90):(p<300?(0.0049163265306122455+(-0.0015195918367346948)*(p-200)/100):(p<400?(0.0033967346938775507+(-0.0007151020408163265)*(p-300)/100):0.0026816326530612242)))))))))+((p<=0?0.13371428571428573:(p<10?(0.13371428571428573+(-0.033428571428571446)*(p-0)/10):(p<25?(0.10028571428571428+(-0.044571428571428574)*(p-10)/15):(p<50?(0.05571428571428571+(-0.033428571428571426)*(p-25)/25):(p<100?(0.022285714285714284+(-0.010474285714285712)*(p-50)/50):(p<110?(0.011811428571428572+(-0.0006685714285714298)*(p-100)/10):(p<200?(0.011142857142857142+(-0.0050142857142857124)*(p-110)/90):(p<300?(0.006128571428571429+(-0.0018942857142857155)*(p-200)/100):(p<400?(0.004234285714285714+(-0.0008914285714285712)*(p-300)/100):0.0033428571428571426)))))))))-(p<=0?0.10726530612244897:(p<10?(0.10726530612244897+(-0.026816326530612236)*(p-0)/10):(p<25?(0.08044897959183674+(-0.035755102040816326)*(p-10)/15):(p<50?(0.04469387755102041+(-0.026816326530612247)*(p-25)/25):(p<100?(0.017877551020408163+(-0.008402448979591838)*(p-50)/50):(p<110?(0.009475102040816325+(-0.0005363265306122435)*(p-100)/10):(p<200?(0.008938775510204082+(-0.004022448979591836)*(p-110)/90):(p<300?(0.0049163265306122455+(-0.0015195918367346948)*(p-200)/100):(p<400?(0.0033967346938775507+(-0.0007151020408163265)*(p-300)/100):0.0026816326530612242))))))))))*(g-(-2))/2):(g<2?((p<=0?0.13371428571428573:(p<10?(0.13371428571428573+(-0.033428571428571446)*(p-0)/10):(p<25?(0.10028571428571428+(-0.044571428571428574)*(p-10)/15):(p<50?(0.05571428571428571+(-0.033428571428571426)*(p-25)/25):(p<100?(0.022285714285714284+(-0.010474285714285712)*(p-50)/50):(p<110?(0.011811428571428572+(-0.0006685714285714298)*(p-100)/10):(p<200?(0.011142857142857142+(-0.0050142857142857124)*(p-110)/90):(p<300?(0.006128571428571429+(-0.0018942857142857155)*(p-200)/100):(p<400?(0.004234285714285714+(-0.0008914285714285712)*(p-300)/100):0.0033428571428571426)))))))))+((p<=0?0.16212244897959183:(p<10?(0.16212244897959183+(-0.04053061224489796)*(p-0)/10):(p<25?(0.12159183673469387+(-0.0540408163265306)*(p-10)/15):(p<50?(0.06755102040816327+(-0.040530612244897964)*(p-25)/25):(p<100?(0.027020408163265307+(-0.012699591836734693)*(p-50)/50):(p<110?(0.014320816326530613+(-0.00081061224489796)*(p-100)/10):(p<200?(0.013510204081632653+(-0.006079591836734693)*(p-110)/90):(p<300?(0.00743061224489796+(-0.0022967346938775517)*(p-200)/100):(p<400?(0.005133877551020408+(-0.0010808163265306134)*(p-300)/100):0.004053061224489795)))))))))-(p<=0?0.13371428571428573:(p<10?(0.13371428571428573+(-0.033428571428571446)*(p-0)/10):(p<25?(0.10028571428571428+(-0.044571428571428574)*(p-10)/15):(p<50?(0.05571428571428571+(-0.033428571428571426)*(p-25)/25):(p<100?(0.022285714285714284+(-0.010474285714285712)*(p-50)/50):(p<110?(0.011811428571428572+(-0.0006685714285714298)*(p-100)/10):(p<200?(0.011142857142857142+(-0.0050142857142857124)*(p-110)/90):(p<300?(0.006128571428571429+(-0.0018942857142857155)*(p-200)/100):(p<400?(0.004234285714285714+(-0.0008914285714285712)*(p-300)/100):0.0033428571428571426))))))))))*(g-(0))/2):(g<4?((p<=0?0.16212244897959183:(p<10?(0.16212244897959183+(-0.04053061224489796)*(p-0)/10):(p<25?(0.12159183673469387+(-0.0540408163265306)*(p-10)/15):(p<50?(0.06755102040816327+(-0.040530612244897964)*(p-25)/25):(p<100?(0.027020408163265307+(-0.012699591836734693)*(p-50)/50):(p<110?(0.014320816326530613+(-0.00081061224489796)*(p-100)/10):(p<200?(0.013510204081632653+(-0.006079591836734693)*(p-110)/90):(p<300?(0.00743061224489796+(-0.0022967346938775517)*(p-200)/100):(p<400?(0.005133877551020408+(-0.0010808163265306134)*(p-300)/100):0.004053061224489795)))))))))+((p<=0?0.18955102040816324:(p<10?(0.18955102040816324+(-0.047387755102040796)*(p-0)/10):(p<25?(0.14216326530612244+(-0.06318367346938776)*(p-10)/15):(p<50?(0.07897959183673468+(-0.04738775510204081)*(p-25)/25):(p<100?(0.03159183673469387+(-0.014848163265306118)*(p-50)/50):(p<110?(0.016743673469387755+(-0.0009477551020408183)*(p-100)/10):(p<200?(0.015795918367346937+(-0.0071081632653061215)*(p-110)/90):(p<300?(0.008687755102040815+(-0.002685306122448979)*(p-200)/100):(p<400?(0.006002448979591836+(-0.001263673469387755)*(p-300)/100):0.004738775510204081)))))))))-(p<=0?0.16212244897959183:(p<10?(0.16212244897959183+(-0.04053061224489796)*(p-0)/10):(p<25?(0.12159183673469387+(-0.0540408163265306)*(p-10)/15):(p<50?(0.06755102040816327+(-0.040530612244897964)*(p-25)/25):(p<100?(0.027020408163265307+(-0.012699591836734693)*(p-50)/50):(p<110?(0.014320816326530613+(-0.00081061224489796)*(p-100)/10):(p<200?(0.013510204081632653+(-0.006079591836734693)*(p-110)/90):(p<300?(0.00743061224489796+(-0.0022967346938775517)*(p-200)/100):(p<400?(0.005133877551020408+(-0.0010808163265306134)*(p-300)/100):0.004053061224489795))))))))))*(g-(2))/2):(g<6?((p<=0?0.18955102040816324:(p<10?(0.18955102040816324+(-0.047387755102040796)*(p-0)/10):(p<25?(0.14216326530612244+(-0.06318367346938776)*(p-10)/15):(p<50?(0.07897959183673468+(-0.04738775510204081)*(p-25)/25):(p<100?(0.03159183673469387+(-0.014848163265306118)*(p-50)/50):(p<110?(0.016743673469387755+(-0.0009477551020408183)*(p-100)/10):(p<200?(0.015795918367346937+(-0.0071081632653061215)*(p-110)/90):(p<300?(0.008687755102040815+(-0.002685306122448979)*(p-200)/100):(p<400?(0.006002448979591836+(-0.001263673469387755)*(p-300)/100):0.004738775510204081)))))))))+((p<=0?0.21893877551020405:(p<10?(0.21893877551020405+(-0.054734693877551005)*(p-0)/10):(p<25?(0.16420408163265304+(-0.07297959183673468)*(p-10)/15):(p<50?(0.09122448979591836+(-0.054734693877551026)*(p-25)/25):(p<100?(0.03648979591836734+(-0.017150204081632647)*(p-50)/50):(p<110?(0.01933959183673469+(-0.0010946938775510222)*(p-100)/10):(p<200?(0.01824489795918367+(-0.00821020408163265)*(p-110)/90):(p<300?(0.010034693877551019+(-0.003101632653061224)*(p-200)/100):(p<400?(0.006933061224489795+(-0.0014595918367346934)*(p-300)/100):0.005473469387755101)))))))))-(p<=0?0.18955102040816324:(p<10?(0.18955102040816324+(-0.047387755102040796)*(p-0)/10):(p<25?(0.14216326530612244+(-0.06318367346938776)*(p-10)/15):(p<50?(0.07897959183673468+(-0.04738775510204081)*(p-25)/25):(p<100?(0.03159183673469387+(-0.014848163265306118)*(p-50)/50):(p<110?(0.016743673469387755+(-0.0009477551020408183)*(p-100)/10):(p<200?(0.015795918367346937+(-0.0071081632653061215)*(p-110)/90):(p<300?(0.008687755102040815+(-0.002685306122448979)*(p-200)/100):(p<400?(0.006002448979591836+(-0.001263673469387755)*(p-300)/100):0.004738775510204081))))))))))*(g-(4))/2):(p<=0?0.21893877551020405:(p<10?(0.21893877551020405+(-0.054734693877551005)*(p-0)/10):(p<25?(0.16420408163265304+(-0.07297959183673468)*(p-10)/15):(p<50?(0.09122448979591836+(-0.054734693877551026)*(p-25)/25):(p<100?(0.03648979591836734+(-0.017150204081632647)*(p-50)/50):(p<110?(0.01933959183673469+(-0.0010946938775510222)*(p-100)/10):(p<200?(0.01824489795918367+(-0.00821020408163265)*(p-110)/90):(p<300?(0.010034693877551019+(-0.003101632653061224)*(p-200)/100):(p<400?(0.006933061224489795+(-0.0014595918367346934)*(p-300)/100):0.005473469387755101))))))))))))))))))))))}
.func Q(s) {max(s,1e-6)/110}
RRF N_BPLUS_FILT 0 15000
C25 N_BPLUS_FILT 0 2e-8
BSIGNAL INPUT 0 V={0.05*sin(6283.185307179586*(time-0.35))*(time >= 0.35)}
RDET INPUT H 50000
C15 H 0 2.5e-10
R16TOP H W 200000
R16BOT W 0 300000
R19 G 0 4700000
R21 N_BPLUS_FILT P 470000
BTRI P 0 I={1*TRI(max(V(P),0),V(G))}
BTRIG G 0 I={1e-7*exp(min(5,V(G)/0.2))}
R23 O 0 470000
R24 K 0 130
C22 K 0 2.5e-10
BOP T K I={1*(V(N_BPLUS_FILT,K)>0)*Q(V(N_BPLUS_FILT,K))^1.5*OUTP(max(V(T,K),0)/Q(V(N_BPLUS_FILT,K)),V(O,K)/Q(V(N_BPLUS_FILT,K)))}
BOS N_BPLUS_FILT K I={1*(V(N_BPLUS_FILT,K)>0)*Q(V(N_BPLUS_FILT,K))^1.5*OUTS(max(V(T,K),0)/Q(V(N_BPLUS_FILT,K)),V(O,K)/Q(V(N_BPLUS_FILT,K)))}
BOG O K I={0.0007*(V(N_BPLUS_FILT,K)>0)*max(V(O,K),0)^1.5}
R26 N_BPLUS_RECT X 200
L26 X T 5 IC=0
BSPEAKER SPEAKER 0 V={V(X,T)/25}
C18 W G 1e-8 IC=0
C20 P O 1e-8 IC=0
RREF X T 2000
.tran 0.000010416666666666666 0.6 0.5 0.000010416666666666666 UIC
.print tran V(N_BPLUS_RECT) V(N_BPLUS_FILT) V(P) V(K) V(O) V(SPEAKER)
.end
