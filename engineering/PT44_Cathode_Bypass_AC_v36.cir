* PT-44 source-traced 50L6 cathode-bypass branch — v0.36.0
* Philco 1941 RMS p.38: #22 250 pF is across #24 130 ohm cathode resistor.
* Isolated branch only; this is not an output-stage or receiver model.
VTEST SOURCE 0 AC 1
RSOURCE SOURCE K_CATH 1000
R24 K_CATH 0 130
C22 K_CATH 0 250p
.ac lin 455 1000 455000
.print ac vm(K_CATH)
.end
